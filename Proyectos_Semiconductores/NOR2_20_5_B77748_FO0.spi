*** SPICE deck for cell NOR2_20_5_B77748_FO0{lay} from library IE0311_B77748_II2024
*** Created on lun nov 04, 2024 22:04:46
*** Last revised on mar nov 05, 2024 22:45:16
*** Written on mar nov 05, 2024 22:45:39 by Electric VLSI Design System, version 9.07
*** Layout tech: mocmos, foundry MOSIS
*** UC SPICE *** , MIN_RESIST 4.0, MIN_CAPAC 0.1FF
***    P-Active:	areacap=0.9FF/um^2,	edgecap=0.0FF/um,	res=2.5ohms/sq
***    N-Active:	areacap=0.9FF/um^2,	edgecap=0.0FF/um,	res=3.0ohms/sq
***    Polysilicon-1:	areacap=0.1467FF/um^2,	edgecap=0.0608FF/um,	res=6.2ohms/sq
***    Polysilicon-2:	areacap=1.0FF/um^2,	edgecap=0.0FF/um,	res=50.0ohms/sq
***    Transistor-Poly:	areacap=0.09FF/um^2,	edgecap=0.0FF/um,	res=2.5ohms/sq
***    Poly-Cut:	areacap=0.0FF/um^2,	edgecap=0.0FF/um,	res=2.2ohms/sq
***    Active-Cut:	areacap=0.0FF/um^2,	edgecap=0.0FF/um,	res=2.5ohms/sq
***    Metal-1:	areacap=0.1209FF/um^2,	edgecap=0.1104FF/um,	res=0.078ohms/sq
***    Via1:	areacap=0.0FF/um^2,	edgecap=0.0FF/um,	res=1.0ohms/sq
***    Metal-2:	areacap=0.0843FF/um^2,	edgecap=0.0974FF/um,	res=0.078ohms/sq
***    Via2:	areacap=0.0FF/um^2,	edgecap=0.0FF/um,	res=0.9ohms/sq
***    Metal-3:	areacap=0.0843FF/um^2,	edgecap=0.0974FF/um,	res=0.078ohms/sq
***    Via3:	areacap=0.0FF/um^2,	edgecap=0.0FF/um,	res=0.8ohms/sq
***    Metal-4:	areacap=0.0843FF/um^2,	edgecap=0.0974FF/um,	res=0.078ohms/sq
***    Via4:	areacap=0.0FF/um^2,	edgecap=0.0FF/um,	res=0.8ohms/sq
***    Metal-5:	areacap=0.0843FF/um^2,	edgecap=0.0974FF/um,	res=0.078ohms/sq
***    Via5:	areacap=0.0FF/um^2,	edgecap=0.0FF/um,	res=0.8ohms/sq
***    Metal-6:	areacap=0.0423FF/um^2,	edgecap=0.1273FF/um,	res=0.036ohms/sq
***    Hi-Res:	areacap=0.0FF/um^2,	edgecap=0.0FF/um,	res=1.0ohms/sq

*** SUBCIRCUIT IE0311_B77748_II2024__NOR2_20_5_B77748 FROM CELL NOR2_20_5_B77748{lay}
.SUBCKT IE0311_B77748_II2024__NOR2_20_5_B77748 A_B77748 B_B77748 gnd vdd Y_B77748
Mnmos@0 gnd B_B77748#2nmos@0_poly-right Y_B77748 gnd NMOS L=0.4U W=1U AS=2.2P AD=2.6P PS=6.2U PD=7.2U
Mnmos@1 Y_B77748 A_B77748#2nmos@1_poly-right gnd gnd NMOS L=0.4U W=1U AS=2.6P AD=2.2P PS=7.2U PD=6.2U
Mpmos@0 net@75 B_B77748#0pmos@0_poly-left Y_B77748 vdd PMOS L=0.4U W=4U AS=2.2P AD=2.4P PS=6.2U PD=5.2U
Mpmos@1 vdd A_B77748#0pmos@1_poly-left net@75 vdd PMOS L=0.4U W=4U AS=2.4P AD=8.4P PS=5.2U PD=20.2U
** Extracted Parasitic Capacitors ***
C0 Y_B77748 0 6.446fF
C1 A_B77748#2nmos@1_poly-right 0 0.101fF
C2 A_B77748#1pin@19_polysilicon-1 0 0.263fF
C3 B_B77748#1pin@21_polysilicon-1 0 0.274fF
** Extracted Parasitic Resistors ***
R0 A_B77748#0pmos@1_poly-left A_B77748#0pmos@1_poly-left##0 8.783
R1 A_B77748#0pmos@1_poly-left##0 A_B77748#0pmos@1_poly-left##1 8.783
R2 A_B77748#0pmos@1_poly-left##1 A_B77748#1pin@19_polysilicon-1 8.783
R3 A_B77748#1pin@19_polysilicon-1 A_B77748#1pin@19_polysilicon-1##0 9.644
C4 A_B77748#1pin@19_polysilicon-1##0 0 0.101fF
R4 A_B77748#1pin@19_polysilicon-1##0 A_B77748#1pin@19_polysilicon-1##1 9.644
C5 A_B77748#1pin@19_polysilicon-1##1 0 0.101fF
R5 A_B77748#1pin@19_polysilicon-1##1 A_B77748#1pin@19_polysilicon-1##2 9.644
C6 A_B77748#1pin@19_polysilicon-1##2 0 0.101fF
R6 A_B77748#1pin@19_polysilicon-1##2 A_B77748#1pin@19_polysilicon-1##3 9.644
C7 A_B77748#1pin@19_polysilicon-1##3 0 0.101fF
R7 A_B77748#1pin@19_polysilicon-1##3 A_B77748#1pin@19_polysilicon-1##4 9.644
C8 A_B77748#1pin@19_polysilicon-1##4 0 0.101fF
R8 A_B77748#1pin@19_polysilicon-1##4 A_B77748#1pin@19_polysilicon-1##5 9.644
C9 A_B77748#1pin@19_polysilicon-1##5 0 0.101fF
R9 A_B77748#1pin@19_polysilicon-1##5 A_B77748#1pin@19_polysilicon-1##6 9.644
C10 A_B77748#1pin@19_polysilicon-1##6 0 0.101fF
R10 A_B77748#1pin@19_polysilicon-1##6 A_B77748#1pin@19_polysilicon-1##7 9.644
C11 A_B77748#1pin@19_polysilicon-1##7 0 0.101fF
R11 A_B77748#1pin@19_polysilicon-1##7 A_B77748#2nmos@1_poly-right 9.644
R12 A_B77748#1pin@19_polysilicon-1 A_B77748#1pin@19_polysilicon-1##0 9.817
R13 A_B77748#1pin@19_polysilicon-1##0 A_B77748#1pin@19_polysilicon-1##1 9.817
R14 A_B77748#1pin@19_polysilicon-1##1 A_B77748 9.817
R15 B_B77748#0pmos@0_poly-left B_B77748#0pmos@0_poly-left##0 9.92
R16 B_B77748#0pmos@0_poly-left##0 B_B77748#0pmos@0_poly-left##1 9.92
R17 B_B77748#0pmos@0_poly-left##1 B_B77748#0pmos@0_poly-left##2 9.92
R18 B_B77748#0pmos@0_poly-left##2 B_B77748#0pmos@0_poly-left##3 9.92
R19 B_B77748#0pmos@0_poly-left##3 B_B77748#1pin@21_polysilicon-1 9.92
R20 B_B77748#1pin@21_polysilicon-1 B_B77748#1pin@21_polysilicon-1##0 9.079
R21 B_B77748#1pin@21_polysilicon-1##0 B_B77748#1pin@21_polysilicon-1##1 9.079
R22 B_B77748#1pin@21_polysilicon-1##1 B_B77748#1pin@21_polysilicon-1##2 9.079
R23 B_B77748#1pin@21_polysilicon-1##2 B_B77748#1pin@21_polysilicon-1##3 9.079
R24 B_B77748#1pin@21_polysilicon-1##3 B_B77748#1pin@21_polysilicon-1##4 9.079
R25 B_B77748#1pin@21_polysilicon-1##4 B_B77748#1pin@21_polysilicon-1##5 9.079
R26 B_B77748#1pin@21_polysilicon-1##5 B_B77748#2nmos@0_poly-right 9.079
R27 B_B77748#1pin@21_polysilicon-1 B_B77748#1pin@21_polysilicon-1##0 9.817
R28 B_B77748#1pin@21_polysilicon-1##0 B_B77748#1pin@21_polysilicon-1##1 9.817
R29 B_B77748#1pin@21_polysilicon-1##1 B_B77748 9.817
.ENDS IE0311_B77748_II2024__NOR2_20_5_B77748

*** TOP LEVEL CELL: NOR2_20_5_B77748_FO0{lay}
XNOR2_20_@3 A B GND VDD Y IE0311_B77748_II2024__NOR2_20_5_B77748
** Extracted Parasitic Capacitors ***
C0 A 0 0.826fF
C1 B 0 0.73fF
C2 Y 0 0.794fF
C3 GND 0 0.87fF
C4 VDD 0 0.663fF
** Extracted Parasitic Resistors ***

* Spice Code nodes in cell cell 'NOR2_20_5_B77748_FO0{lay}'
.include \Universidad\DispositivosSemiconductores\Lab3_B77748_IE0311\spice.txt
Vgnd GND 0 DC 0
Vdd VDD 0 DC 5
VB B 0 DC 0
VA A 0 PULSE 0 5 10n 0.1n 0.1n 7.54n 15.48n
.tran 0 100n
.MEAS t_rise_nor_fo0 time TRIG V(A)=2.5 FALL=1 TARG V(Y)=2.5 RISE=1
.MEAS t_fall_nor_fo0 time TRIG V(A)=2.5 RISE=1 TARG V(Y)=2.5 FALL=1
.END
.END
