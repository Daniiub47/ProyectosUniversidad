*** SPICE deck for cell NAND2_10_10_B77748_FO4{lay} from library IE0311_B77748_II2024
*** Created on mar nov 05, 2024 17:28:50
*** Last revised on mar nov 05, 2024 22:31:40
*** Written on mar nov 05, 2024 22:32:48 by Electric VLSI Design System, version 9.07
*** Layout tech: mocmos, foundry MOSIS
*** UC SPICE *** , MIN_RESIST 4.0, MIN_CAPAC 0.1FF
***    P-Active:	areacap=0.9FF/um^2,	edgecap=0.0FF/um,	res=2.5ohms/sq
***    N-Active:	areacap=0.9FF/um^2,	edgecap=0.0FF/um,	res=3.0ohms/sq
***    Polysilicon-1:	areacap=0.1467FF/um^2,	edgecap=0.0608FF/um,	res=6.2ohms/sq
***    Polysilicon-2:	areacap=1.0FF/um^2,	edgecap=0.0FF/um,	res=50.0ohms/sq
***    Transistor-Poly:	areacap=0.09FF/um^2,	edgecap=0.0FF/um,	res=2.5ohms/sq
***    Poly-Cut:	areacap=0.0FF/um^2,	edgecap=0.0FF/um,	res=2.2ohms/sq
***    Active-Cut:	areacap=0.0FF/um^2,	edgecap=0.0FF/um,	res=2.5ohms/sq
***    Metal-1:	areacap=0.1209FF/um^2,	edgecap=0.1104FF/um,	res=0.078ohms/sq
***    Via1:	areacap=0.0FF/um^2,	edgecap=0.0FF/um,	res=1.0ohms/sq
***    Metal-2:	areacap=0.0843FF/um^2,	edgecap=0.0974FF/um,	res=0.078ohms/sq
***    Via2:	areacap=0.0FF/um^2,	edgecap=0.0FF/um,	res=0.9ohms/sq
***    Metal-3:	areacap=0.0843FF/um^2,	edgecap=0.0974FF/um,	res=0.078ohms/sq
***    Via3:	areacap=0.0FF/um^2,	edgecap=0.0FF/um,	res=0.8ohms/sq
***    Metal-4:	areacap=0.0843FF/um^2,	edgecap=0.0974FF/um,	res=0.078ohms/sq
***    Via4:	areacap=0.0FF/um^2,	edgecap=0.0FF/um,	res=0.8ohms/sq
***    Metal-5:	areacap=0.0843FF/um^2,	edgecap=0.0974FF/um,	res=0.078ohms/sq
***    Via5:	areacap=0.0FF/um^2,	edgecap=0.0FF/um,	res=0.8ohms/sq
***    Metal-6:	areacap=0.0423FF/um^2,	edgecap=0.1273FF/um,	res=0.036ohms/sq
***    Hi-Res:	areacap=0.0FF/um^2,	edgecap=0.0FF/um,	res=1.0ohms/sq

*** SUBCIRCUIT IE0311_B77748_II2024__INV_20_10_B77748 FROM CELL INV_20_10_B77748{lay}
.SUBCKT IE0311_B77748_II2024__INV_20_10_B77748 A_B77748 gnd vdd Y_B77748
Mnmos@0 Y_B77748 A_B77748#2nmos@0_poly-right gnd gnd NMOS L=0.4U W=2U AS=7P AD=3.3P PS=16.6U PD=8.2U
Mpmos@0 Y_B77748 A_B77748#0pmos@0_poly-left vdd vdd PMOS L=0.4U W=4U AS=9.2P AD=3.3P PS=20.6U PD=8.2U
** Extracted Parasitic Capacitors ***
C0 Y_B77748 0 2.858fF
C1 A_B77748#1pin@14_polysilicon-1 0 0.219fF
** Extracted Parasitic Resistors ***
R0 A_B77748#0pmos@0_poly-left A_B77748#0pmos@0_poly-left##0 8.525
R1 A_B77748#0pmos@0_poly-left##0 A_B77748#0pmos@0_poly-left##1 8.525
R2 A_B77748#0pmos@0_poly-left##1 A_B77748#0pmos@0_poly-left##2 8.525
R3 A_B77748#0pmos@0_poly-left##2 A_B77748#0pmos@0_poly-left##3 8.525
R4 A_B77748#0pmos@0_poly-left##3 A_B77748#0pmos@0_poly-left##4 8.525
R5 A_B77748#0pmos@0_poly-left##4 A_B77748#1pin@14_polysilicon-1 8.525
R6 A_B77748#1pin@14_polysilicon-1 A_B77748#1pin@14_polysilicon-1##0 9.817
R7 A_B77748#1pin@14_polysilicon-1##0 A_B77748#1pin@14_polysilicon-1##1 9.817
R8 A_B77748#1pin@14_polysilicon-1##1 A_B77748#2nmos@0_poly-right 9.817
R9 A_B77748 A_B77748##0 6.2
R10 A_B77748##0 A_B77748#1pin@14_polysilicon-1 6.2
.ENDS IE0311_B77748_II2024__INV_20_10_B77748

*** SUBCIRCUIT IE0311_B77748_II2024__NAND2_10_10_B77748 FROM CELL NAND2_10_10_B77748{lay}
.SUBCKT IE0311_B77748_II2024__NAND2_10_10_B77748 A_B77748 B_B77748 gnd vdd Y_B77748
Mnmos@0 net@16 B_B77748#2nmos@0_poly-right gnd gnd NMOS L=0.4U W=2U AS=6.2P AD=1.2P PS=16.2U PD=3.2U
Mnmos@1 Y_B77748 A_B77748#2nmos@1_poly-right net@16 gnd NMOS L=0.4U W=2U AS=1.2P AD=2.2P PS=3.2U PD=6.2U
Mpmos@0 vdd B_B77748#0pmos@0_poly-left Y_B77748 vdd PMOS L=0.4U W=2U AS=2.2P AD=3.2P PS=6.2U PD=8.2U
Mpmos@1 Y_B77748 A_B77748#0pmos@1_poly-left vdd vdd PMOS L=0.4U W=2U AS=3.2P AD=2.2P PS=8.2U PD=6.2U
** Extracted Parasitic Capacitors ***
C0 Y_B77748 0 6.573fF
C1 A_B77748#1pin@16_polysilicon-1 0 0.259fF
C2 B_B77748#1pin@17_polysilicon-1 0 0.258fF
C3 B_B77748#0pmos@0_poly-left 0 0.105fF
** Extracted Parasitic Resistors ***
R0 A_B77748#0pmos@1_poly-left A_B77748#0pmos@1_poly-left##0 9.3
R1 A_B77748#0pmos@1_poly-left##0 A_B77748#0pmos@1_poly-left##1 9.3
R2 A_B77748#0pmos@1_poly-left##1 A_B77748#0pmos@1_poly-left##2 9.3
R3 A_B77748#0pmos@1_poly-left##2 A_B77748#0pmos@1_poly-left##3 9.3
R4 A_B77748#0pmos@1_poly-left##3 A_B77748#0pmos@1_poly-left##4 9.3
R5 A_B77748#0pmos@1_poly-left##4 A_B77748#0pmos@1_poly-left##5 9.3
R6 A_B77748#0pmos@1_poly-left##5 A_B77748#1pin@16_polysilicon-1 9.3
R7 A_B77748#1pin@16_polysilicon-1 A_B77748#1pin@16_polysilicon-1##0 9.3
R8 A_B77748#1pin@16_polysilicon-1##0 A_B77748#1pin@16_polysilicon-1##1 9.3
R9 A_B77748#1pin@16_polysilicon-1##1 A_B77748#1pin@16_polysilicon-1##2 9.3
R10 A_B77748#1pin@16_polysilicon-1##2 A_B77748#1pin@16_polysilicon-1##3 9.3
R11 A_B77748#1pin@16_polysilicon-1##3 A_B77748#1pin@16_polysilicon-1##4 9.3
R12 A_B77748#1pin@16_polysilicon-1##4 A_B77748#2nmos@1_poly-right 9.3
R13 A_B77748#1pin@16_polysilicon-1 A_B77748#1pin@16_polysilicon-1##0 7.75
R14 A_B77748#1pin@16_polysilicon-1##0 A_B77748#1pin@16_polysilicon-1##1 7.75
R15 A_B77748#1pin@16_polysilicon-1##1 A_B77748#1pin@16_polysilicon-1##2 7.75
R16 A_B77748#1pin@16_polysilicon-1##2 A_B77748 7.75
R17 B_B77748#0pmos@0_poly-left B_B77748#0pmos@0_poly-left##0 9.989
C4 B_B77748#0pmos@0_poly-left##0 0 0.105fF
R18 B_B77748#0pmos@0_poly-left##0 B_B77748#0pmos@0_poly-left##1 9.989
C5 B_B77748#0pmos@0_poly-left##1 0 0.105fF
R19 B_B77748#0pmos@0_poly-left##1 B_B77748#0pmos@0_poly-left##2 9.989
C6 B_B77748#0pmos@0_poly-left##2 0 0.105fF
R20 B_B77748#0pmos@0_poly-left##2 B_B77748#0pmos@0_poly-left##3 9.989
C7 B_B77748#0pmos@0_poly-left##3 0 0.105fF
R21 B_B77748#0pmos@0_poly-left##3 B_B77748#0pmos@0_poly-left##4 9.989
C8 B_B77748#0pmos@0_poly-left##4 0 0.105fF
R22 B_B77748#0pmos@0_poly-left##4 B_B77748#0pmos@0_poly-left##5 9.989
C9 B_B77748#0pmos@0_poly-left##5 0 0.105fF
R23 B_B77748#0pmos@0_poly-left##5 B_B77748#0pmos@0_poly-left##6 9.989
C10 B_B77748#0pmos@0_poly-left##6 0 0.105fF
R24 B_B77748#0pmos@0_poly-left##6 B_B77748#0pmos@0_poly-left##7 9.989
C11 B_B77748#0pmos@0_poly-left##7 0 0.105fF
R25 B_B77748#0pmos@0_poly-left##7 B_B77748#1pin@17_polysilicon-1 9.989
R26 B_B77748#1pin@17_polysilicon-1 B_B77748#1pin@17_polysilicon-1##0 7.75
R27 B_B77748#1pin@17_polysilicon-1##0 B_B77748#1pin@17_polysilicon-1##1 7.75
R28 B_B77748#1pin@17_polysilicon-1##1 B_B77748#1pin@17_polysilicon-1##2 7.75
R29 B_B77748#1pin@17_polysilicon-1##2 B_B77748#2nmos@0_poly-right 7.75
R30 B_B77748#1pin@17_polysilicon-1 B_B77748#1pin@17_polysilicon-1##0 9.3
R31 B_B77748#1pin@17_polysilicon-1##0 B_B77748#1pin@17_polysilicon-1##1 9.3
R32 B_B77748#1pin@17_polysilicon-1##1 B_B77748 9.3
.ENDS IE0311_B77748_II2024__NAND2_10_10_B77748

*** TOP LEVEL CELL: NAND2_10_10_B77748_FO4{lay}
XINV_20_1@0 Y GND1 VDD1 Y1 IE0311_B77748_II2024__INV_20_10_B77748
XINV_20_1@1 Y GND2 VDD2 Y2 IE0311_B77748_II2024__INV_20_10_B77748
XINV_20_1@2 Y GND3 VDD3 Y3 IE0311_B77748_II2024__INV_20_10_B77748
XINV_20_1@3 Y GND4 VDD4 Y4 IE0311_B77748_II2024__INV_20_10_B77748
XNAND2_10@0 A B GND VDD Y IE0311_B77748_II2024__NAND2_10_10_B77748
** Extracted Parasitic Capacitors ***
C0 Y 0 29.275fF
C1 Y1 0 1.365fF
C2 GND1 0 0.911fF
C3 VDD1 0 1.367fF
C4 Y2 0 1.365fF
C5 GND2 0 0.87fF
C6 VDD2 0 0.953fF
C7 Y3 0 1.461fF
C8 GND3 0 1.036fF
C9 VDD3 0 0.994fF
C10 Y4 0 1.492fF
C11 GND4 0 1.077fF
C12 VDD4 0 0.911fF
C13 A 0 0.794fF
C14 B 0 0.73fF
C15 GND 0 0.953fF
C16 VDD 0 0.746fF
** Extracted Parasitic Resistors ***

* Spice Code nodes in cell cell 'NAND2_10_10_B77748_FO4{lay}'
.include \Universidad\DispositivosSemiconductores\Lab3_B77748_IE0311\spice.txt
Vgnd GND 0 DC 0
Vdd VDD 0 DC 5
VB B 0 DC 5
VA A 0 PULSE 0 5 10n 0.1n 0.1n 7.54n 15.48n
.tran 0 100n
.MEAS t_rise_nand_fo4 time TRIG V(A)=2.5 FALL=1 TARG V(Y)=2.5 RISE=1
.MEAS t_fall_nand_fo4 time TRIG V(A)=2.5 RISE=1 TARG V(Y)=2.5 FALL=1
.END
.END
