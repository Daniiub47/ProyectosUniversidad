*** SPICE deck for cell MUX_2_1_CompPaso_sim{lay} from library IE0311_B77748_B45211_II2024
*** Created on Sun Dec 01, 2024 10:26:31
*** Last revised on Sun Dec 01, 2024 12:52:08
*** Written on Sun Dec 01, 2024 12:52:22 by Electric VLSI Design System, version 9.07
*** Layout tech: mocmos, foundry MOSIS
*** UC SPICE *** , MIN_RESIST 4.0, MIN_CAPAC 0.1FF
***    P-Active:	areacap=0.9FF/um^2,	edgecap=0.0FF/um,	res=2.5ohms/sq
***    N-Active:	areacap=0.9FF/um^2,	edgecap=0.0FF/um,	res=3.0ohms/sq
***    Polysilicon-1:	areacap=0.1467FF/um^2,	edgecap=0.0608FF/um,	res=6.2ohms/sq
***    Polysilicon-2:	areacap=1.0FF/um^2,	edgecap=0.0FF/um,	res=50.0ohms/sq
***    Transistor-Poly:	areacap=0.09FF/um^2,	edgecap=0.0FF/um,	res=2.5ohms/sq
***    Poly-Cut:	areacap=0.0FF/um^2,	edgecap=0.0FF/um,	res=2.2ohms/sq
***    Active-Cut:	areacap=0.0FF/um^2,	edgecap=0.0FF/um,	res=2.5ohms/sq
***    Metal-1:	areacap=0.1209FF/um^2,	edgecap=0.1104FF/um,	res=0.078ohms/sq
***    Via1:	areacap=0.0FF/um^2,	edgecap=0.0FF/um,	res=1.0ohms/sq
***    Metal-2:	areacap=0.0843FF/um^2,	edgecap=0.0974FF/um,	res=0.078ohms/sq
***    Via2:	areacap=0.0FF/um^2,	edgecap=0.0FF/um,	res=0.9ohms/sq
***    Metal-3:	areacap=0.0843FF/um^2,	edgecap=0.0974FF/um,	res=0.078ohms/sq
***    Via3:	areacap=0.0FF/um^2,	edgecap=0.0FF/um,	res=0.8ohms/sq
***    Metal-4:	areacap=0.0843FF/um^2,	edgecap=0.0974FF/um,	res=0.078ohms/sq
***    Via4:	areacap=0.0FF/um^2,	edgecap=0.0FF/um,	res=0.8ohms/sq
***    Metal-5:	areacap=0.0843FF/um^2,	edgecap=0.0974FF/um,	res=0.078ohms/sq
***    Via5:	areacap=0.0FF/um^2,	edgecap=0.0FF/um,	res=0.8ohms/sq
***    Metal-6:	areacap=0.0423FF/um^2,	edgecap=0.1273FF/um,	res=0.036ohms/sq
***    Hi-Res:	areacap=0.0FF/um^2,	edgecap=0.0FF/um,	res=1.0ohms/sq

*** SUBCIRCUIT IE0311_B77748_B45211_II2024__MUX_2_1_CompPaso_B77748_B45211 FROM CELL MUX_2_1_CompPaso_B77748_B45211{lay}
.SUBCKT IE0311_B77748_B45211_II2024__MUX_2_1_CompPaso_B77748_B45211 A_B77748 B_B77748 gnd sel_B77748 vdd Y_B77748
Mnmos@0 A_B77748 sel_B77748#5nmos@0_poly-left Y_B77748 gnd NMOS L=0.4U W=2U AS=2.8P AD=2.8P PS=6.8U PD=6.8U
Mnmos@1 Y_B77748 net@98#10nmos@1_poly-left B_B77748 gnd NMOS L=0.4U W=2U AS=2.8P AD=2.8P PS=6.8U PD=6.8U
Mnmos@2 net@98 sel_B77748#0nmos@2_poly-right gnd gnd NMOS L=0.4U W=2U AS=15P AD=3.3P PS=36.6U PD=8.2U
Mpmos@0 A_B77748 net@98#6pmos@0_poly-right Y_B77748 vdd PMOS L=0.4U W=2U AS=2.8P AD=2.8P PS=6.8U PD=6.8U
Mpmos@1 Y_B77748 sel_B77748#10pmos@1_poly-right B_B77748 vdd PMOS L=0.4U W=2U AS=2.8P AD=2.8P PS=6.8U PD=6.8U
Mpmos@2 net@98 sel_B77748#2pmos@2_poly-left vdd vdd PMOS L=0.4U W=4U AS=17.2P AD=3.3P PS=40.6U PD=8.2U
** Extracted Parasitic Capacitors ***
C0 A_B77748 0 3.556fF
C1 Y_B77748 0 9.008fF
C2 B_B77748 0 3.842fF
C3 net@98 0 3.649fF
C4 net@98#8contact@35_metal-1-polysilicon-1 0 1.196fF
C5 sel_B77748#1pin@49_polysilicon-1 0 0.362fF
C6 net@98#7pin@59_polysilicon-1 0 0.258fF
C7 sel_B77748#4pin@60_polysilicon-1 0 0.27fF
C8 sel_B77748#6pin@61_polysilicon-1 0 0.174fF
C9 sel_B77748#7pin@62_polysilicon-1 0 0.174fF
C10 sel_B77748#8pin@63_polysilicon-1 0 0.186fF
C11 net@98#11pin@66_polysilicon-1 0 0.137fF
** Extracted Parasitic Resistors ***
R0 sel_B77748#0nmos@2_poly-right sel_B77748#0nmos@2_poly-right##0 8.783
R1 sel_B77748#0nmos@2_poly-right##0 sel_B77748#0nmos@2_poly-right##1 8.783
R2 sel_B77748#0nmos@2_poly-right##1 sel_B77748#1pin@49_polysilicon-1 8.783
R3 sel_B77748#1pin@49_polysilicon-1 sel_B77748#1pin@49_polysilicon-1##0 9.042
R4 sel_B77748#1pin@49_polysilicon-1##0 sel_B77748#1pin@49_polysilicon-1##1 9.042
R5 sel_B77748#1pin@49_polysilicon-1##1 sel_B77748#1pin@49_polysilicon-1##2 9.042
R6 sel_B77748#1pin@49_polysilicon-1##2 sel_B77748#1pin@49_polysilicon-1##3 9.042
R7 sel_B77748#1pin@49_polysilicon-1##3 sel_B77748#1pin@49_polysilicon-1##4 9.042
R8 sel_B77748#1pin@49_polysilicon-1##4 sel_B77748#2pmos@2_poly-left 9.042
R9 sel_B77748#1pin@49_polysilicon-1 sel_B77748#1pin@49_polysilicon-1##0 9.92
R10 sel_B77748#1pin@49_polysilicon-1##0 sel_B77748#1pin@49_polysilicon-1##1 9.92
R11 sel_B77748#1pin@49_polysilicon-1##1 sel_B77748#1pin@49_polysilicon-1##2 9.92
R12 sel_B77748#1pin@49_polysilicon-1##2 sel_B77748#1pin@49_polysilicon-1##3 9.92
R13 sel_B77748#1pin@49_polysilicon-1##3 sel_B77748 9.92
R14 net@98#6pmos@0_poly-right net@98#6pmos@0_poly-right##0 8.783
R15 net@98#6pmos@0_poly-right##0 net@98#6pmos@0_poly-right##1 8.783
R16 net@98#6pmos@0_poly-right##1 net@98#6pmos@0_poly-right##2 8.783
R17 net@98#6pmos@0_poly-right##2 net@98#6pmos@0_poly-right##3 8.783
R18 net@98#6pmos@0_poly-right##3 net@98#6pmos@0_poly-right##4 8.783
R19 net@98#6pmos@0_poly-right##4 net@98#7pin@59_polysilicon-1 8.783
R20 net@98#7pin@59_polysilicon-1 net@98#7pin@59_polysilicon-1##0 9.3
R21 net@98#7pin@59_polysilicon-1##0 net@98#7pin@59_polysilicon-1##1 9.3
R22 net@98#7pin@59_polysilicon-1##1 net@98#7pin@59_polysilicon-1##2 9.3
R23 net@98#7pin@59_polysilicon-1##2 net@98#7pin@59_polysilicon-1##3 9.3
R24 net@98#7pin@59_polysilicon-1##3 net@98#7pin@59_polysilicon-1##4 9.3
R25 net@98#7pin@59_polysilicon-1##4 net@98 9.3
R26 sel_B77748#1pin@49_polysilicon-1 sel_B77748#1pin@49_polysilicon-1##0 9.3
R27 sel_B77748#1pin@49_polysilicon-1##0 sel_B77748#1pin@49_polysilicon-1##1 9.3
R28 sel_B77748#1pin@49_polysilicon-1##1 sel_B77748#1pin@49_polysilicon-1##2 9.3
R29 sel_B77748#1pin@49_polysilicon-1##2 sel_B77748#1pin@49_polysilicon-1##3 9.3
R30 sel_B77748#1pin@49_polysilicon-1##3 sel_B77748#1pin@49_polysilicon-1##4 9.3
R31 sel_B77748#1pin@49_polysilicon-1##4 sel_B77748#1pin@49_polysilicon-1##5 9.3
R32 sel_B77748#1pin@49_polysilicon-1##5 sel_B77748#1pin@49_polysilicon-1##6 9.3
R33 sel_B77748#1pin@49_polysilicon-1##6 sel_B77748#1pin@49_polysilicon-1##7 9.3
R34 sel_B77748#1pin@49_polysilicon-1##7 sel_B77748#1pin@49_polysilicon-1##8 9.3
R35 sel_B77748#1pin@49_polysilicon-1##8 sel_B77748#1pin@49_polysilicon-1##9 9.3
R36 sel_B77748#1pin@49_polysilicon-1##9 sel_B77748#4pin@60_polysilicon-1 9.3
R37 net@98#7pin@59_polysilicon-1 net@98#7pin@59_polysilicon-1##0 8.06
R38 net@98#7pin@59_polysilicon-1##0 net@98#7pin@59_polysilicon-1##1 8.06
R39 net@98#7pin@59_polysilicon-1##1 net@98#7pin@59_polysilicon-1##2 8.06
R40 net@98#7pin@59_polysilicon-1##2 net@98#7pin@59_polysilicon-1##3 8.06
R41 net@98#7pin@59_polysilicon-1##3 net@98#8contact@35_metal-1-polysilicon-1 8.06
R42 sel_B77748#5nmos@0_poly-left sel_B77748#5nmos@0_poly-left##0 9.3
R43 sel_B77748#5nmos@0_poly-left##0 sel_B77748#5nmos@0_poly-left##1 9.3
R44 sel_B77748#5nmos@0_poly-left##1 sel_B77748#4pin@60_polysilicon-1 9.3
R45 sel_B77748#4pin@60_polysilicon-1 sel_B77748#4pin@60_polysilicon-1##0 8.857
R46 sel_B77748#4pin@60_polysilicon-1##0 sel_B77748#4pin@60_polysilicon-1##1 8.857
R47 sel_B77748#4pin@60_polysilicon-1##1 sel_B77748#4pin@60_polysilicon-1##2 8.857
R48 sel_B77748#4pin@60_polysilicon-1##2 sel_B77748#4pin@60_polysilicon-1##3 8.857
R49 sel_B77748#4pin@60_polysilicon-1##3 sel_B77748#4pin@60_polysilicon-1##4 8.857
R50 sel_B77748#4pin@60_polysilicon-1##4 sel_B77748#4pin@60_polysilicon-1##5 8.857
R51 sel_B77748#4pin@60_polysilicon-1##5 sel_B77748#6pin@61_polysilicon-1 8.857
R52 sel_B77748#6pin@61_polysilicon-1 sel_B77748#6pin@61_polysilicon-1##0 8.68
R53 sel_B77748#6pin@61_polysilicon-1##0 sel_B77748#6pin@61_polysilicon-1##1 8.68
R54 sel_B77748#6pin@61_polysilicon-1##1 sel_B77748#6pin@61_polysilicon-1##2 8.68
R55 sel_B77748#6pin@61_polysilicon-1##2 sel_B77748#6pin@61_polysilicon-1##3 8.68
R56 sel_B77748#6pin@61_polysilicon-1##3 sel_B77748#7pin@62_polysilicon-1 8.68
R57 sel_B77748#7pin@62_polysilicon-1 sel_B77748#7pin@62_polysilicon-1##0 9.3
R58 sel_B77748#7pin@62_polysilicon-1##0 sel_B77748#7pin@62_polysilicon-1##1 9.3
R59 sel_B77748#7pin@62_polysilicon-1##1 sel_B77748#7pin@62_polysilicon-1##2 9.3
R60 sel_B77748#7pin@62_polysilicon-1##2 sel_B77748#7pin@62_polysilicon-1##3 9.3
R61 sel_B77748#7pin@62_polysilicon-1##3 sel_B77748#8pin@63_polysilicon-1 9.3
R62 sel_B77748#10pmos@1_poly-right sel_B77748#10pmos@1_poly-right##0 8.06
R63 sel_B77748#10pmos@1_poly-right##0 sel_B77748#10pmos@1_poly-right##1 8.06
R64 sel_B77748#10pmos@1_poly-right##1 sel_B77748#10pmos@1_poly-right##2 8.06
R65 sel_B77748#10pmos@1_poly-right##2 sel_B77748#10pmos@1_poly-right##3 8.06
R66 sel_B77748#10pmos@1_poly-right##3 sel_B77748#8pin@63_polysilicon-1 8.06
R67 net@98#10nmos@1_poly-left net@98#11pin@66_polysilicon-1 6.2
R68 net@98#11pin@66_polysilicon-1 net@98#11pin@66_polysilicon-1##0 9.964
C12 net@98#11pin@66_polysilicon-1##0 0 0.101fF
R69 net@98#11pin@66_polysilicon-1##0 net@98#11pin@66_polysilicon-1##1 9.964
C13 net@98#11pin@66_polysilicon-1##1 0 0.101fF
R70 net@98#11pin@66_polysilicon-1##1 net@98#11pin@66_polysilicon-1##2 9.964
C14 net@98#11pin@66_polysilicon-1##2 0 0.101fF
R71 net@98#11pin@66_polysilicon-1##2 net@98#11pin@66_polysilicon-1##3 9.964
C15 net@98#11pin@66_polysilicon-1##3 0 0.101fF
R72 net@98#11pin@66_polysilicon-1##3 net@98#11pin@66_polysilicon-1##4 9.964
C16 net@98#11pin@66_polysilicon-1##4 0 0.101fF
R73 net@98#11pin@66_polysilicon-1##4 net@98#11pin@66_polysilicon-1##5 9.964
C17 net@98#11pin@66_polysilicon-1##5 0 0.101fF
R74 net@98#11pin@66_polysilicon-1##5 net@98#8contact@35_metal-1-polysilicon-1 9.964
.ENDS IE0311_B77748_B45211_II2024__MUX_2_1_CompPaso_B77748_B45211

*** TOP LEVEL CELL: MUX_2_1_CompPaso_sim{lay}
XMUX_2_1_@0 Va Vb GND sel Vdd Vout IE0311_B77748_B45211_II2024__MUX_2_1_CompPaso_B77748_B45211
** Extracted Parasitic Capacitors ***
C0 Va 0 2.54fF
C1 Vb 0 1.207fF
C2 Vout 0 1.207fF
C3 GND 0 0.87fF
C4 sel 0 0.191fF
C5 Vdd 0 1.45fF
** Extracted Parasitic Resistors ***

* Spice Code nodes in cell cell 'MUX_2_1_CompPaso_sim{lay}'
.include C:\Users\vboxuser\Documents\spice.txt
* Definir la fuente de alimentacion
VDD VDD 0 DC 5
*Tierra
VGND GND DC 0
.tran 0 100n
VS   sel   0 PULSE 0 5 2n 0.1n 0.1n  25n 50n
VA   Va   0 PULSE 0 5 5n 0.1n 0.1n  10n 20n
* Para probar despues el funcionamiento
VB   Vb   0 PULSE 0 5 40n 0.1n 0.1n  10n 20n
* Medicion del retardo de subida
.MEAS t_rise time TRIG V(Va)=2.5 RISE=2 TARG V(Vout)=2.5 RISE=2
.MEAS t_fall time TRIG V(Va)=2.5 FALL=1 TARG V(Vout)=2.5 FALL=1
.END
