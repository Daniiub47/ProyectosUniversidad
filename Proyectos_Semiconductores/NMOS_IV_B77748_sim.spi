*** SPICE deck for cell NMOS_IV_B77748_sim{lay} from library IE0311_B77748_II2024
*** Created on sáb sep 14, 2024 18:06:25
*** Last revised on dom sep 15, 2024 00:47:02
*** Written on dom sep 15, 2024 00:47:45 by Electric VLSI Design System, version 9.07
*** Layout tech: mocmos, foundry MOSIS
*** UC SPICE *** , MIN_RESIST 4.0, MIN_CAPAC 0.1FF
***    P-Active:	areacap=0.9FF/um^2,	edgecap=0.0FF/um,	res=2.5ohms/sq
***    N-Active:	areacap=0.9FF/um^2,	edgecap=0.0FF/um,	res=3.0ohms/sq
***    Polysilicon-1:	areacap=0.1467FF/um^2,	edgecap=0.0608FF/um,	res=6.2ohms/sq
***    Polysilicon-2:	areacap=1.0FF/um^2,	edgecap=0.0FF/um,	res=50.0ohms/sq
***    Transistor-Poly:	areacap=0.09FF/um^2,	edgecap=0.0FF/um,	res=2.5ohms/sq
***    Poly-Cut:	areacap=0.0FF/um^2,	edgecap=0.0FF/um,	res=2.2ohms/sq
***    Active-Cut:	areacap=0.0FF/um^2,	edgecap=0.0FF/um,	res=2.5ohms/sq
***    Metal-1:	areacap=0.1209FF/um^2,	edgecap=0.1104FF/um,	res=0.078ohms/sq
***    Via1:	areacap=0.0FF/um^2,	edgecap=0.0FF/um,	res=1.0ohms/sq
***    Metal-2:	areacap=0.0843FF/um^2,	edgecap=0.0974FF/um,	res=0.078ohms/sq
***    Via2:	areacap=0.0FF/um^2,	edgecap=0.0FF/um,	res=0.9ohms/sq
***    Metal-3:	areacap=0.0843FF/um^2,	edgecap=0.0974FF/um,	res=0.078ohms/sq
***    Via3:	areacap=0.0FF/um^2,	edgecap=0.0FF/um,	res=0.8ohms/sq
***    Metal-4:	areacap=0.0843FF/um^2,	edgecap=0.0974FF/um,	res=0.078ohms/sq
***    Via4:	areacap=0.0FF/um^2,	edgecap=0.0FF/um,	res=0.8ohms/sq
***    Metal-5:	areacap=0.0843FF/um^2,	edgecap=0.0974FF/um,	res=0.078ohms/sq
***    Via5:	areacap=0.0FF/um^2,	edgecap=0.0FF/um,	res=0.8ohms/sq
***    Metal-6:	areacap=0.0423FF/um^2,	edgecap=0.1273FF/um,	res=0.036ohms/sq
***    Hi-Res:	areacap=0.0FF/um^2,	edgecap=0.0FF/um,	res=1.0ohms/sq

*** SUBCIRCUIT IE0311_B77748_II2024__NMOS_IV_B77748 FROM CELL NMOS_IV_B77748{lay}
.SUBCKT IE0311_B77748_II2024__NMOS_IV_B77748 d_B77748 g_B77748 gnd s_B77748
Mnmos@0 s_B77748 g_B77748#0nmos@0_poly-left d_B77748 gnd NMOS L=0.4U W=2U AS=2.4P AD=2.4P PS=6.4U PD=6.4U
** Extracted Parasitic Capacitors ***
C0 d_B77748 0 0.587fF
C1 s_B77748 0 0.587fF
** Extracted Parasitic Resistors ***
R0 g_B77748 g_B77748##0 7.75
R1 g_B77748##0 g_B77748#0nmos@0_poly-left 7.75
.ENDS IE0311_B77748_II2024__NMOS_IV_B77748

*** TOP LEVEL CELL: NMOS_IV_B77748_sim{lay}
XNMOS_IV_@0 Vd Vg GND Vs IE0311_B77748_II2024__NMOS_IV_B77748
** Extracted Parasitic Capacitors ***
C0 Vd 0 0.469fF
C1 Vg 0 0.667fF
C2 GND 0 0.851fF
C3 Vs 0 0.469fF
** Extracted Parasitic Resistors ***

* Spice Code nodes in cell cell 'NMOS_IV_B77748_sim{lay}'
.include \Universidad\DispositivosSemiconductores\Lab1\spice.txt ;
VGND GND 0 DC 0 ;
Vx_var Vg Vs 0 DC {Vgs} ;
Vs Vs 0 DC 0 ;
Vds Vd Vs DC 0 ;
.DC Vds 0 5 1m ;
.step param Vgs 0 5 1 ;
.END
