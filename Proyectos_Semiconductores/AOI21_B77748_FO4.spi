*** SPICE deck for cell AOI21_B77748_FO4{lay} from library IE0311_B77748_II2024
*** Created on mar nov 05, 2024 20:26:32
*** Last revised on mar nov 05, 2024 23:13:37
*** Written on mar nov 05, 2024 23:14:08 by Electric VLSI Design System, version 9.07
*** Layout tech: mocmos, foundry MOSIS
*** UC SPICE *** , MIN_RESIST 4.0, MIN_CAPAC 0.1FF
***    P-Active:	areacap=0.9FF/um^2,	edgecap=0.0FF/um,	res=2.5ohms/sq
***    N-Active:	areacap=0.9FF/um^2,	edgecap=0.0FF/um,	res=3.0ohms/sq
***    Polysilicon-1:	areacap=0.1467FF/um^2,	edgecap=0.0608FF/um,	res=6.2ohms/sq
***    Polysilicon-2:	areacap=1.0FF/um^2,	edgecap=0.0FF/um,	res=50.0ohms/sq
***    Transistor-Poly:	areacap=0.09FF/um^2,	edgecap=0.0FF/um,	res=2.5ohms/sq
***    Poly-Cut:	areacap=0.0FF/um^2,	edgecap=0.0FF/um,	res=2.2ohms/sq
***    Active-Cut:	areacap=0.0FF/um^2,	edgecap=0.0FF/um,	res=2.5ohms/sq
***    Metal-1:	areacap=0.1209FF/um^2,	edgecap=0.1104FF/um,	res=0.078ohms/sq
***    Via1:	areacap=0.0FF/um^2,	edgecap=0.0FF/um,	res=1.0ohms/sq
***    Metal-2:	areacap=0.0843FF/um^2,	edgecap=0.0974FF/um,	res=0.078ohms/sq
***    Via2:	areacap=0.0FF/um^2,	edgecap=0.0FF/um,	res=0.9ohms/sq
***    Metal-3:	areacap=0.0843FF/um^2,	edgecap=0.0974FF/um,	res=0.078ohms/sq
***    Via3:	areacap=0.0FF/um^2,	edgecap=0.0FF/um,	res=0.8ohms/sq
***    Metal-4:	areacap=0.0843FF/um^2,	edgecap=0.0974FF/um,	res=0.078ohms/sq
***    Via4:	areacap=0.0FF/um^2,	edgecap=0.0FF/um,	res=0.8ohms/sq
***    Metal-5:	areacap=0.0843FF/um^2,	edgecap=0.0974FF/um,	res=0.078ohms/sq
***    Via5:	areacap=0.0FF/um^2,	edgecap=0.0FF/um,	res=0.8ohms/sq
***    Metal-6:	areacap=0.0423FF/um^2,	edgecap=0.1273FF/um,	res=0.036ohms/sq
***    Hi-Res:	areacap=0.0FF/um^2,	edgecap=0.0FF/um,	res=1.0ohms/sq

*** SUBCIRCUIT IE0311_B77748_II2024__AOI21_B77748 FROM CELL AOI21_B77748{lay}
.SUBCKT IE0311_B77748_II2024__AOI21_B77748 A_B77748 B_B77748 C_B77748 gnd vdd Y_B77748
Mnmos@0 net@140 A_B77748#3nmos@0_poly-right gnd gnd NMOS L=0.4U W=2U AS=5P AD=1.2P PS=12.9U PD=3.2U
Mnmos@1 Y_B77748 B_B77748#2nmos@1_poly-right net@140 gnd NMOS L=0.4U W=2U AS=1.2P AD=2.533P PS=3.2U PD=6U
Mnmos@2 gnd C_B77748#2nmos@2_poly-right Y_B77748 gnd NMOS L=0.4U W=1U AS=2.533P AD=5P PS=6U PD=12.9U
Mpmos@0 vdd A_B77748#0pmos@0_poly-left net@81 vdd PMOS L=0.4U W=4U AS=4P AD=5.7P PS=7.333U PD=12.8U
Mpmos@1 net@81 B_B77748#0pmos@1_poly-left vdd vdd PMOS L=0.4U W=4U AS=5.7P AD=4P PS=12.8U PD=7.333U
Mpmos@2 Y_B77748 C_B77748#0pmos@2_poly-left net@81 vdd PMOS L=0.4U W=4U AS=4P AD=2.533P PS=7.333U PD=6U
** Extracted Parasitic Capacitors ***
C0 net@81 0 3.016fF
C1 Y_B77748 0 4.35fF
C2 B_B77748#2nmos@1_poly-right 0 0.101fF
C3 C_B77748#1pin@12_polysilicon-1 0 0.244fF
C4 A_B77748#1pin@22_polysilicon-1 0 0.259fF
C5 B_B77748#1pin@25_polysilicon-1 0 0.201fF
C6 A_B77748#0pmos@0_poly-left 0 0.101fF
** Extracted Parasitic Resistors ***
R0 C_B77748#0pmos@2_poly-left C_B77748#0pmos@2_poly-left##0 9.128
R1 C_B77748#0pmos@2_poly-left##0 C_B77748#0pmos@2_poly-left##1 9.128
R2 C_B77748#0pmos@2_poly-left##1 C_B77748#0pmos@2_poly-left##2 9.128
R3 C_B77748#0pmos@2_poly-left##2 C_B77748#0pmos@2_poly-left##3 9.128
R4 C_B77748#0pmos@2_poly-left##3 C_B77748#0pmos@2_poly-left##4 9.128
R5 C_B77748#0pmos@2_poly-left##4 C_B77748#0pmos@2_poly-left##5 9.128
R6 C_B77748#0pmos@2_poly-left##5 C_B77748#0pmos@2_poly-left##6 9.128
R7 C_B77748#0pmos@2_poly-left##6 C_B77748#0pmos@2_poly-left##7 9.128
R8 C_B77748#0pmos@2_poly-left##7 C_B77748#1pin@12_polysilicon-1 9.128
R9 C_B77748#1pin@12_polysilicon-1 C_B77748#1pin@12_polysilicon-1##0 8.783
R10 C_B77748#1pin@12_polysilicon-1##0 C_B77748#1pin@12_polysilicon-1##1 8.783
R11 C_B77748#1pin@12_polysilicon-1##1 C_B77748#2nmos@2_poly-right 8.783
R12 C_B77748#1pin@12_polysilicon-1 C_B77748#1pin@12_polysilicon-1##0 7.75
R13 C_B77748#1pin@12_polysilicon-1##0 C_B77748#1pin@12_polysilicon-1##1 7.75
R14 C_B77748#1pin@12_polysilicon-1##1 C_B77748#1pin@12_polysilicon-1##2 7.75
R15 C_B77748#1pin@12_polysilicon-1##2 C_B77748 7.75
R16 A_B77748#0pmos@0_poly-left A_B77748#0pmos@0_poly-left##0 9.964
C7 A_B77748#0pmos@0_poly-left##0 0 0.101fF
R17 A_B77748#0pmos@0_poly-left##0 A_B77748#0pmos@0_poly-left##1 9.964
C8 A_B77748#0pmos@0_poly-left##1 0 0.101fF
R18 A_B77748#0pmos@0_poly-left##1 A_B77748#0pmos@0_poly-left##2 9.964
C9 A_B77748#0pmos@0_poly-left##2 0 0.101fF
R19 A_B77748#0pmos@0_poly-left##2 A_B77748#0pmos@0_poly-left##3 9.964
C10 A_B77748#0pmos@0_poly-left##3 0 0.101fF
R20 A_B77748#0pmos@0_poly-left##3 A_B77748#0pmos@0_poly-left##4 9.964
C11 A_B77748#0pmos@0_poly-left##4 0 0.101fF
R21 A_B77748#0pmos@0_poly-left##4 A_B77748#0pmos@0_poly-left##5 9.964
C12 A_B77748#0pmos@0_poly-left##5 0 0.101fF
R22 A_B77748#0pmos@0_poly-left##5 A_B77748#1pin@22_polysilicon-1 9.964
R23 A_B77748#1pin@22_polysilicon-1 A_B77748#1pin@22_polysilicon-1##0 9.817
R24 A_B77748#1pin@22_polysilicon-1##0 A_B77748#1pin@22_polysilicon-1##1 9.817
R25 A_B77748#1pin@22_polysilicon-1##1 A_B77748 9.817
R26 A_B77748#3nmos@0_poly-right A_B77748#3nmos@0_poly-right##0 7.75
R27 A_B77748#3nmos@0_poly-right##0 A_B77748#3nmos@0_poly-right##1 7.75
R28 A_B77748#3nmos@0_poly-right##1 A_B77748#3nmos@0_poly-right##2 7.75
R29 A_B77748#3nmos@0_poly-right##2 A_B77748#1pin@22_polysilicon-1 7.75
R30 B_B77748#0pmos@1_poly-left B_B77748#0pmos@1_poly-left##0 7.75
R31 B_B77748#0pmos@1_poly-left##0 B_B77748#0pmos@1_poly-left##1 7.75
R32 B_B77748#0pmos@1_poly-left##1 B_B77748#0pmos@1_poly-left##2 7.75
R33 B_B77748#0pmos@1_poly-left##2 B_B77748#1pin@25_polysilicon-1 7.75
R34 B_B77748#1pin@25_polysilicon-1 B_B77748#1pin@25_polysilicon-1##0 9.964
C13 B_B77748#1pin@25_polysilicon-1##0 0 0.101fF
R35 B_B77748#1pin@25_polysilicon-1##0 B_B77748#1pin@25_polysilicon-1##1 9.964
C14 B_B77748#1pin@25_polysilicon-1##1 0 0.101fF
R36 B_B77748#1pin@25_polysilicon-1##1 B_B77748#1pin@25_polysilicon-1##2 9.964
C15 B_B77748#1pin@25_polysilicon-1##2 0 0.101fF
R37 B_B77748#1pin@25_polysilicon-1##2 B_B77748#1pin@25_polysilicon-1##3 9.964
C16 B_B77748#1pin@25_polysilicon-1##3 0 0.101fF
R38 B_B77748#1pin@25_polysilicon-1##3 B_B77748#1pin@25_polysilicon-1##4 9.964
C17 B_B77748#1pin@25_polysilicon-1##4 0 0.101fF
R39 B_B77748#1pin@25_polysilicon-1##4 B_B77748#1pin@25_polysilicon-1##5 9.964
C18 B_B77748#1pin@25_polysilicon-1##5 0 0.101fF
R40 B_B77748#1pin@25_polysilicon-1##5 B_B77748#2nmos@1_poly-right 9.964
R41 B_B77748#1pin@25_polysilicon-1 B_B77748 4.65
.ENDS IE0311_B77748_II2024__AOI21_B77748

*** SUBCIRCUIT IE0311_B77748_II2024__INV_20_10_B77748 FROM CELL INV_20_10_B77748{lay}
.SUBCKT IE0311_B77748_II2024__INV_20_10_B77748 A_B77748 gnd vdd Y_B77748
Mnmos@0 Y_B77748 A_B77748#2nmos@0_poly-right gnd gnd NMOS L=0.4U W=2U AS=7P AD=3.3P PS=16.6U PD=8.2U
Mpmos@0 Y_B77748 A_B77748#0pmos@0_poly-left vdd vdd PMOS L=0.4U W=4U AS=9.2P AD=3.3P PS=20.6U PD=8.2U
** Extracted Parasitic Capacitors ***
C0 Y_B77748 0 2.858fF
C1 A_B77748#1pin@14_polysilicon-1 0 0.219fF
** Extracted Parasitic Resistors ***
R0 A_B77748#0pmos@0_poly-left A_B77748#0pmos@0_poly-left##0 8.525
R1 A_B77748#0pmos@0_poly-left##0 A_B77748#0pmos@0_poly-left##1 8.525
R2 A_B77748#0pmos@0_poly-left##1 A_B77748#0pmos@0_poly-left##2 8.525
R3 A_B77748#0pmos@0_poly-left##2 A_B77748#0pmos@0_poly-left##3 8.525
R4 A_B77748#0pmos@0_poly-left##3 A_B77748#0pmos@0_poly-left##4 8.525
R5 A_B77748#0pmos@0_poly-left##4 A_B77748#1pin@14_polysilicon-1 8.525
R6 A_B77748#1pin@14_polysilicon-1 A_B77748#1pin@14_polysilicon-1##0 9.817
R7 A_B77748#1pin@14_polysilicon-1##0 A_B77748#1pin@14_polysilicon-1##1 9.817
R8 A_B77748#1pin@14_polysilicon-1##1 A_B77748#2nmos@0_poly-right 9.817
R9 A_B77748 A_B77748##0 6.2
R10 A_B77748##0 A_B77748#1pin@14_polysilicon-1 6.2
.ENDS IE0311_B77748_II2024__INV_20_10_B77748

*** TOP LEVEL CELL: AOI21_B77748_FO4{lay}
XAOI21_B7@0 A B C AOI21_B7@0_gnd AOI21_B7@0_vdd Y IE0311_B77748_II2024__AOI21_B77748
XINV_20_1@0 Y GND1 VDD1 Y1 IE0311_B77748_II2024__INV_20_10_B77748
XINV_20_1@1 Y GND2 VDD2 Y2 IE0311_B77748_II2024__INV_20_10_B77748
XINV_20_1@2 Y GND3 VDD3 Y3 IE0311_B77748_II2024__INV_20_10_B77748
XINV_20_1@3 Y GND4 VDD4 Y4 IE0311_B77748_II2024__INV_20_10_B77748
** Extracted Parasitic Capacitors ***
C0 A 0 1.08fF
C1 B 0 2.223fF
C2 C 0 0.667fF
C3 Y 0 29.021fF
C4 Y1 0 1.365fF
C5 GND1 0 0.911fF
C6 VDD1 0 1.367fF
C7 Y2 0 1.365fF
C8 GND2 0 0.87fF
C9 VDD2 0 0.953fF
C10 Y3 0 1.461fF
C11 GND3 0 1.036fF
C12 VDD3 0 0.994fF
C13 Y4 0 1.492fF
C14 GND4 0 1.077fF
C15 VDD4 0 0.911fF
** Extracted Parasitic Resistors ***

* Spice Code nodes in cell cell 'AOI21_B77748_FO4{lay}'
.include \Universidad\DispositivosSemiconductores\Lab3_B77748_IE0311\spice.txt
Vgnd GND 0 DC 0
Vdd VDD 0 DC 5
VB B 0 DC 2.5
VC C 0 DC 2.5
VA A 0 PULSE 0 5 10n 0.1n 0.1n 7.54n 15.48n
.tran 0 100n
.MEAS t_rise_aoi21_fo4_A time TRIG V(A)=2.5 FALL=1 TARG V(Y)=2.5 RISE=1
.MEAS t_fall_aoi21_fo4_A time TRIG V(A)=2.5 RISE=1 TARG V(Y)=2.5 FALL=1
.END
.END
