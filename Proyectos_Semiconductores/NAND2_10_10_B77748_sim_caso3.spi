*** SPICE deck for cell NAND2_10_10_B77748_sim{lay} from library IE0311_B77748_II2024
*** Created on sáb nov 02, 2024 20:59:53
*** Last revised on lun nov 04, 2024 20:45:38
*** Written on lun nov 04, 2024 20:46:44 by Electric VLSI Design System, version 9.07
*** Layout tech: mocmos, foundry MOSIS
*** UC SPICE *** , MIN_RESIST 4.0, MIN_CAPAC 0.1FF
***    P-Active:	areacap=0.9FF/um^2,	edgecap=0.0FF/um,	res=2.5ohms/sq
***    N-Active:	areacap=0.9FF/um^2,	edgecap=0.0FF/um,	res=3.0ohms/sq
***    Polysilicon-1:	areacap=0.1467FF/um^2,	edgecap=0.0608FF/um,	res=6.2ohms/sq
***    Polysilicon-2:	areacap=1.0FF/um^2,	edgecap=0.0FF/um,	res=50.0ohms/sq
***    Transistor-Poly:	areacap=0.09FF/um^2,	edgecap=0.0FF/um,	res=2.5ohms/sq
***    Poly-Cut:	areacap=0.0FF/um^2,	edgecap=0.0FF/um,	res=2.2ohms/sq
***    Active-Cut:	areacap=0.0FF/um^2,	edgecap=0.0FF/um,	res=2.5ohms/sq
***    Metal-1:	areacap=0.1209FF/um^2,	edgecap=0.1104FF/um,	res=0.078ohms/sq
***    Via1:	areacap=0.0FF/um^2,	edgecap=0.0FF/um,	res=1.0ohms/sq
***    Metal-2:	areacap=0.0843FF/um^2,	edgecap=0.0974FF/um,	res=0.078ohms/sq
***    Via2:	areacap=0.0FF/um^2,	edgecap=0.0FF/um,	res=0.9ohms/sq
***    Metal-3:	areacap=0.0843FF/um^2,	edgecap=0.0974FF/um,	res=0.078ohms/sq
***    Via3:	areacap=0.0FF/um^2,	edgecap=0.0FF/um,	res=0.8ohms/sq
***    Metal-4:	areacap=0.0843FF/um^2,	edgecap=0.0974FF/um,	res=0.078ohms/sq
***    Via4:	areacap=0.0FF/um^2,	edgecap=0.0FF/um,	res=0.8ohms/sq
***    Metal-5:	areacap=0.0843FF/um^2,	edgecap=0.0974FF/um,	res=0.078ohms/sq
***    Via5:	areacap=0.0FF/um^2,	edgecap=0.0FF/um,	res=0.8ohms/sq
***    Metal-6:	areacap=0.0423FF/um^2,	edgecap=0.1273FF/um,	res=0.036ohms/sq
***    Hi-Res:	areacap=0.0FF/um^2,	edgecap=0.0FF/um,	res=1.0ohms/sq

*** SUBCIRCUIT IE0311_B77748_II2024__NAND2_10_10_B77748 FROM CELL NAND2_10_10_B77748{lay}
.SUBCKT IE0311_B77748_II2024__NAND2_10_10_B77748 A_B77748 B_B77748 gnd vdd Y_B77748
Mnmos@0 net@16 B_B77748#2nmos@0_poly-right gnd gnd NMOS L=0.4U W=2U AS=6.2P AD=1.2P PS=16.2U PD=3.2U
Mnmos@1 Y_B77748 A_B77748#2nmos@1_poly-right net@16 gnd NMOS L=0.4U W=2U AS=1.2P AD=2.2P PS=3.2U PD=6.2U
Mpmos@0 vdd B_B77748#0pmos@0_poly-left Y_B77748 vdd PMOS L=0.4U W=2U AS=2.2P AD=3.2P PS=6.2U PD=8.2U
Mpmos@1 Y_B77748 A_B77748#0pmos@1_poly-left vdd vdd PMOS L=0.4U W=2U AS=3.2P AD=2.2P PS=8.2U PD=6.2U
** Extracted Parasitic Capacitors ***
C0 Y_B77748 0 6.573fF
C1 A_B77748#1pin@16_polysilicon-1 0 0.259fF
C2 B_B77748#1pin@17_polysilicon-1 0 0.258fF
C3 B_B77748#0pmos@0_poly-left 0 0.105fF
** Extracted Parasitic Resistors ***
R0 A_B77748#0pmos@1_poly-left A_B77748#0pmos@1_poly-left##0 9.3
R1 A_B77748#0pmos@1_poly-left##0 A_B77748#0pmos@1_poly-left##1 9.3
R2 A_B77748#0pmos@1_poly-left##1 A_B77748#0pmos@1_poly-left##2 9.3
R3 A_B77748#0pmos@1_poly-left##2 A_B77748#0pmos@1_poly-left##3 9.3
R4 A_B77748#0pmos@1_poly-left##3 A_B77748#0pmos@1_poly-left##4 9.3
R5 A_B77748#0pmos@1_poly-left##4 A_B77748#0pmos@1_poly-left##5 9.3
R6 A_B77748#0pmos@1_poly-left##5 A_B77748#1pin@16_polysilicon-1 9.3
R7 A_B77748#1pin@16_polysilicon-1 A_B77748#1pin@16_polysilicon-1##0 9.3
R8 A_B77748#1pin@16_polysilicon-1##0 A_B77748#1pin@16_polysilicon-1##1 9.3
R9 A_B77748#1pin@16_polysilicon-1##1 A_B77748#1pin@16_polysilicon-1##2 9.3
R10 A_B77748#1pin@16_polysilicon-1##2 A_B77748#1pin@16_polysilicon-1##3 9.3
R11 A_B77748#1pin@16_polysilicon-1##3 A_B77748#1pin@16_polysilicon-1##4 9.3
R12 A_B77748#1pin@16_polysilicon-1##4 A_B77748#2nmos@1_poly-right 9.3
R13 A_B77748#1pin@16_polysilicon-1 A_B77748#1pin@16_polysilicon-1##0 7.75
R14 A_B77748#1pin@16_polysilicon-1##0 A_B77748#1pin@16_polysilicon-1##1 7.75
R15 A_B77748#1pin@16_polysilicon-1##1 A_B77748#1pin@16_polysilicon-1##2 7.75
R16 A_B77748#1pin@16_polysilicon-1##2 A_B77748 7.75
R17 B_B77748#0pmos@0_poly-left B_B77748#0pmos@0_poly-left##0 9.989
C4 B_B77748#0pmos@0_poly-left##0 0 0.105fF
R18 B_B77748#0pmos@0_poly-left##0 B_B77748#0pmos@0_poly-left##1 9.989
C5 B_B77748#0pmos@0_poly-left##1 0 0.105fF
R19 B_B77748#0pmos@0_poly-left##1 B_B77748#0pmos@0_poly-left##2 9.989
C6 B_B77748#0pmos@0_poly-left##2 0 0.105fF
R20 B_B77748#0pmos@0_poly-left##2 B_B77748#0pmos@0_poly-left##3 9.989
C7 B_B77748#0pmos@0_poly-left##3 0 0.105fF
R21 B_B77748#0pmos@0_poly-left##3 B_B77748#0pmos@0_poly-left##4 9.989
C8 B_B77748#0pmos@0_poly-left##4 0 0.105fF
R22 B_B77748#0pmos@0_poly-left##4 B_B77748#0pmos@0_poly-left##5 9.989
C9 B_B77748#0pmos@0_poly-left##5 0 0.105fF
R23 B_B77748#0pmos@0_poly-left##5 B_B77748#0pmos@0_poly-left##6 9.989
C10 B_B77748#0pmos@0_poly-left##6 0 0.105fF
R24 B_B77748#0pmos@0_poly-left##6 B_B77748#0pmos@0_poly-left##7 9.989
C11 B_B77748#0pmos@0_poly-left##7 0 0.105fF
R25 B_B77748#0pmos@0_poly-left##7 B_B77748#1pin@17_polysilicon-1 9.989
R26 B_B77748#1pin@17_polysilicon-1 B_B77748#1pin@17_polysilicon-1##0 7.75
R27 B_B77748#1pin@17_polysilicon-1##0 B_B77748#1pin@17_polysilicon-1##1 7.75
R28 B_B77748#1pin@17_polysilicon-1##1 B_B77748#1pin@17_polysilicon-1##2 7.75
R29 B_B77748#1pin@17_polysilicon-1##2 B_B77748#2nmos@0_poly-right 7.75
R30 B_B77748#1pin@17_polysilicon-1 B_B77748#1pin@17_polysilicon-1##0 9.3
R31 B_B77748#1pin@17_polysilicon-1##0 B_B77748#1pin@17_polysilicon-1##1 9.3
R32 B_B77748#1pin@17_polysilicon-1##1 B_B77748 9.3
.ENDS IE0311_B77748_II2024__NAND2_10_10_B77748

*** TOP LEVEL CELL: NAND2_10_10_B77748_sim{lay}
XNAND2_10@0 A1 B1 GND1 VDD1 Y1 IE0311_B77748_II2024__NAND2_10_10_B77748
XNAND2_10@1 A2 B2 GND2 VDD2 Y2 IE0311_B77748_II2024__NAND2_10_10_B77748
XNAND2_10@2 VAB VAB GND3 VDD3 Y3 IE0311_B77748_II2024__NAND2_10_10_B77748
** Extracted Parasitic Capacitors ***
C0 A1 0 0.73fF
C1 B1 0 0.857fF
C2 Y1 0 0.699fF
C3 GND1 0 1.077fF
C4 VDD1 0 1.077fF
C5 A2 0 0.826fF
C6 B2 0 0.857fF
C7 Y2 0 0.794fF
C8 GND2 0 1.036fF
C9 VDD2 0 1.118fF
C10 VAB 0 11.812fF
C11 Y3 0 0.794fF
C12 GND3 0 0.953fF
C13 VDD3 0 1.036fF
** Extracted Parasitic Resistors ***

* Spice Code nodes in cell cell 'NAND2_10_10_B77748_sim{lay}'
*.include \Universidad\DispositivosSemiconductores\Lab3_B77748_IE0311\spice.txt
*Vgnd1 GND1 0 DC 0
*Vdd1 VDD1 0 DC 5
*VA1 A1 0 DC 0
*VB1 B1 0 DC 5
*.DC VA1 0 5 1m
*.include \Universidad\DispositivosSemiconductores\Lab3_B77748_IE0311\spice.txt
*Vgnd2 GND2 0 DC 0
*Vdd2 VDD2 0 DC 5
*VA2 A2 0 DC 5
*VB2 B2 0 DC 0
*.DC VB2 0 5 1m
.include \Universidad\DispositivosSemiconductores\Lab3_B77748_IE0311\spice.txt
Vgnd3 GND3 0 DC 0
Vdd3 VDD3 0 DC 5
Vin VAB 0 DC 0
.DC Vin 0 5 1m
.END
