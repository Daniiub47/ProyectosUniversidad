*** SPICE deck for cell MUX_2_1_NAND2_10_10_sim{lay} from library IE0311_B77748_B45211_II2024
*** Created on Sun Dec 01, 2024 12:48:52
*** Last revised on Sun Dec 01, 2024 12:50:35
*** Written on Sun Dec 01, 2024 12:50:57 by Electric VLSI Design System, version 9.07
*** Layout tech: mocmos, foundry MOSIS
*** UC SPICE *** , MIN_RESIST 4.0, MIN_CAPAC 0.1FF
***    P-Active:	areacap=0.9FF/um^2,	edgecap=0.0FF/um,	res=2.5ohms/sq
***    N-Active:	areacap=0.9FF/um^2,	edgecap=0.0FF/um,	res=3.0ohms/sq
***    Polysilicon-1:	areacap=0.1467FF/um^2,	edgecap=0.0608FF/um,	res=6.2ohms/sq
***    Polysilicon-2:	areacap=1.0FF/um^2,	edgecap=0.0FF/um,	res=50.0ohms/sq
***    Transistor-Poly:	areacap=0.09FF/um^2,	edgecap=0.0FF/um,	res=2.5ohms/sq
***    Poly-Cut:	areacap=0.0FF/um^2,	edgecap=0.0FF/um,	res=2.2ohms/sq
***    Active-Cut:	areacap=0.0FF/um^2,	edgecap=0.0FF/um,	res=2.5ohms/sq
***    Metal-1:	areacap=0.1209FF/um^2,	edgecap=0.1104FF/um,	res=0.078ohms/sq
***    Via1:	areacap=0.0FF/um^2,	edgecap=0.0FF/um,	res=1.0ohms/sq
***    Metal-2:	areacap=0.0843FF/um^2,	edgecap=0.0974FF/um,	res=0.078ohms/sq
***    Via2:	areacap=0.0FF/um^2,	edgecap=0.0FF/um,	res=0.9ohms/sq
***    Metal-3:	areacap=0.0843FF/um^2,	edgecap=0.0974FF/um,	res=0.078ohms/sq
***    Via3:	areacap=0.0FF/um^2,	edgecap=0.0FF/um,	res=0.8ohms/sq
***    Metal-4:	areacap=0.0843FF/um^2,	edgecap=0.0974FF/um,	res=0.078ohms/sq
***    Via4:	areacap=0.0FF/um^2,	edgecap=0.0FF/um,	res=0.8ohms/sq
***    Metal-5:	areacap=0.0843FF/um^2,	edgecap=0.0974FF/um,	res=0.078ohms/sq
***    Via5:	areacap=0.0FF/um^2,	edgecap=0.0FF/um,	res=0.8ohms/sq
***    Metal-6:	areacap=0.0423FF/um^2,	edgecap=0.1273FF/um,	res=0.036ohms/sq
***    Hi-Res:	areacap=0.0FF/um^2,	edgecap=0.0FF/um,	res=1.0ohms/sq

*** SUBCIRCUIT IE0311_B77748_B45211_II2024__MUX_2_1_NAND2_10_10_B77748_B45211 FROM CELL MUX_2_1_NAND2_10_10_B77748_B45211{lay}
.SUBCKT IE0311_B77748_B45211_II2024__MUX_2_1_NAND2_10_10_B77748_B45211 A_B77748 B_B77748 gnd sel_B77748 vdd Y_B77748
Mnmos@11 net@191 net@294#6nmos@11_poly-right gnd gnd NMOS L=0.4U W=2U AS=6.4P AD=1.2P PS=16.3U PD=3.2U
Mnmos@12 net@190 B_B77748#2nmos@12_poly-right net@191 gnd NMOS L=0.4U W=2U AS=1.2P AD=2.2P PS=3.2U PD=6.2U
Mnmos@13 net@224 sel_B77748#2nmos@13_poly-right gnd gnd NMOS L=0.4U W=2U AS=6.4P AD=1.2P PS=16.3U PD=3.2U
Mnmos@14 net@223 A_B77748#2nmos@14_poly-right net@224 gnd NMOS L=0.4U W=2U AS=1.2P AD=2.2P PS=3.2U PD=6.2U
Mnmos@15 net@257 net@223#13nmos@15_poly-right Y_B77748 gnd NMOS L=0.4U W=2U AS=2.2P AD=1.2P PS=6.2U PD=3.2U
Mnmos@16 gnd net@190#13nmos@16_poly-right net@257 gnd NMOS L=0.4U W=2U AS=1.2P AD=6.4P PS=3.2U PD=16.3U
Mnmos@17 net@294 sel_B77748#7nmos@17_poly-right gnd gnd NMOS L=0.4U W=2U AS=6.4P AD=3.3P PS=16.3U PD=8.2U
Mpmos@11 vdd net@294#4pmos@11_poly-left net@190 vdd PMOS L=0.4U W=2U AS=2.2P AD=4.057P PS=6.2U PD=9.971U
Mpmos@12 net@190 B_B77748#0pmos@12_poly-left vdd vdd PMOS L=0.4U W=2U AS=4.057P AD=2.2P PS=9.971U PD=6.2U
Mpmos@13 vdd sel_B77748#0pmos@13_poly-left net@223 vdd PMOS L=0.4U W=2U AS=2.2P AD=4.057P PS=6.2U PD=9.971U
Mpmos@14 net@223 A_B77748#0pmos@14_poly-left vdd vdd PMOS L=0.4U W=2U AS=4.057P AD=2.2P PS=9.971U PD=6.2U
Mpmos@15 vdd net@223#11pmos@15_poly-left Y_B77748 vdd PMOS L=0.4U W=2U AS=2.2P AD=4.057P PS=6.2U PD=9.971U
Mpmos@16 Y_B77748 net@190#11pmos@16_poly-left vdd vdd PMOS L=0.4U W=2U AS=4.057P AD=2.2P PS=9.971U PD=6.2U
Mpmos@17 net@294 sel_B77748#5pmos@17_poly-left vdd vdd PMOS L=0.4U W=4U AS=4.057P AD=3.3P PS=9.971U PD=8.2U
** Extracted Parasitic Capacitors ***
C0 net@190 0 12.625fF
C1 B_B77748 0 3.193fF
C2 net@223 0 7.956fF
C3 A_B77748 0 6.156fF
C4 sel_B77748 0 7.537fF
C5 Y_B77748 0 6.636fF
C6 net@294 0 4.232fF
C7 B_B77748#1pin@90_polysilicon-1 0 0.255fF
C8 A_B77748#1pin@105_polysilicon-1 0 0.259fF
C9 sel_B77748#1pin@106_polysilicon-1 0 0.258fF
C10 net@190#12pin@120_polysilicon-1 0 0.243fF
C11 net@223#12pin@121_polysilicon-1 0 0.269fF
C12 sel_B77748#6pin@140_polysilicon-1 0 0.24fF
C13 net@294#5pin@141_polysilicon-1 0 0.249fF
C14 B_B77748#0pmos@12_poly-left 0 0.102fF
C15 net@190#11pmos@16_poly-left 0 0.1fF
** Extracted Parasitic Resistors ***
R0 B_B77748#0pmos@12_poly-left B_B77748#0pmos@12_poly-left##0 9.881
C16 B_B77748#0pmos@12_poly-left##0 0 0.102fF
R1 B_B77748#0pmos@12_poly-left##0 B_B77748#0pmos@12_poly-left##1 9.881
C17 B_B77748#0pmos@12_poly-left##1 0 0.102fF
R2 B_B77748#0pmos@12_poly-left##1 B_B77748#0pmos@12_poly-left##2 9.881
C18 B_B77748#0pmos@12_poly-left##2 0 0.102fF
R3 B_B77748#0pmos@12_poly-left##2 B_B77748#0pmos@12_poly-left##3 9.881
C19 B_B77748#0pmos@12_poly-left##3 0 0.102fF
R4 B_B77748#0pmos@12_poly-left##3 B_B77748#0pmos@12_poly-left##4 9.881
C20 B_B77748#0pmos@12_poly-left##4 0 0.102fF
R5 B_B77748#0pmos@12_poly-left##4 B_B77748#0pmos@12_poly-left##5 9.881
C21 B_B77748#0pmos@12_poly-left##5 0 0.102fF
R6 B_B77748#0pmos@12_poly-left##5 B_B77748#0pmos@12_poly-left##6 9.881
C22 B_B77748#0pmos@12_poly-left##6 0 0.102fF
R7 B_B77748#0pmos@12_poly-left##6 B_B77748#1pin@90_polysilicon-1 9.881
R8 B_B77748#1pin@90_polysilicon-1 B_B77748#1pin@90_polysilicon-1##0 8.37
R9 B_B77748#1pin@90_polysilicon-1##0 B_B77748#1pin@90_polysilicon-1##1 8.37
R10 B_B77748#1pin@90_polysilicon-1##1 B_B77748#1pin@90_polysilicon-1##2 8.37
R11 B_B77748#1pin@90_polysilicon-1##2 B_B77748#1pin@90_polysilicon-1##3 8.37
R12 B_B77748#1pin@90_polysilicon-1##3 B_B77748#2nmos@12_poly-right 8.37
R13 B_B77748#1pin@90_polysilicon-1 B_B77748#1pin@90_polysilicon-1##0 7.75
R14 B_B77748#1pin@90_polysilicon-1##0 B_B77748#1pin@90_polysilicon-1##1 7.75
R15 B_B77748#1pin@90_polysilicon-1##1 B_B77748#1pin@90_polysilicon-1##2 7.75
R16 B_B77748#1pin@90_polysilicon-1##2 B_B77748 7.75
R17 A_B77748#0pmos@14_poly-left A_B77748#0pmos@14_poly-left##0 9.3
R18 A_B77748#0pmos@14_poly-left##0 A_B77748#0pmos@14_poly-left##1 9.3
R19 A_B77748#0pmos@14_poly-left##1 A_B77748#0pmos@14_poly-left##2 9.3
R20 A_B77748#0pmos@14_poly-left##2 A_B77748#0pmos@14_poly-left##3 9.3
R21 A_B77748#0pmos@14_poly-left##3 A_B77748#0pmos@14_poly-left##4 9.3
R22 A_B77748#0pmos@14_poly-left##4 A_B77748#0pmos@14_poly-left##5 9.3
R23 A_B77748#0pmos@14_poly-left##5 A_B77748#1pin@105_polysilicon-1 9.3
R24 A_B77748#1pin@105_polysilicon-1 A_B77748#1pin@105_polysilicon-1##0 9.3
R25 A_B77748#1pin@105_polysilicon-1##0 A_B77748#1pin@105_polysilicon-1##1 9.3
R26 A_B77748#1pin@105_polysilicon-1##1 A_B77748#1pin@105_polysilicon-1##2 9.3
R27 A_B77748#1pin@105_polysilicon-1##2 A_B77748#1pin@105_polysilicon-1##3 9.3
R28 A_B77748#1pin@105_polysilicon-1##3 A_B77748#1pin@105_polysilicon-1##4 9.3
R29 A_B77748#1pin@105_polysilicon-1##4 A_B77748#2nmos@14_poly-right 9.3
R30 A_B77748#1pin@105_polysilicon-1 A_B77748#1pin@105_polysilicon-1##0 7.75
R31 A_B77748#1pin@105_polysilicon-1##0 A_B77748#1pin@105_polysilicon-1##1 7.75
R32 A_B77748#1pin@105_polysilicon-1##1 A_B77748#1pin@105_polysilicon-1##2 7.75
R33 A_B77748#1pin@105_polysilicon-1##2 A_B77748 7.75
R34 sel_B77748#0pmos@13_poly-left sel_B77748#0pmos@13_poly-left##0 9.455
R35 sel_B77748#0pmos@13_poly-left##0 sel_B77748#0pmos@13_poly-left##1 9.455
R36 sel_B77748#0pmos@13_poly-left##1 sel_B77748#0pmos@13_poly-left##2 9.455
R37 sel_B77748#0pmos@13_poly-left##2 sel_B77748#0pmos@13_poly-left##3 9.455
R38 sel_B77748#0pmos@13_poly-left##3 sel_B77748#0pmos@13_poly-left##4 9.455
R39 sel_B77748#0pmos@13_poly-left##4 sel_B77748#0pmos@13_poly-left##5 9.455
R40 sel_B77748#0pmos@13_poly-left##5 sel_B77748#0pmos@13_poly-left##6 9.455
R41 sel_B77748#0pmos@13_poly-left##6 sel_B77748#0pmos@13_poly-left##7 9.455
R42 sel_B77748#0pmos@13_poly-left##7 sel_B77748#0pmos@13_poly-left##8 9.455
R43 sel_B77748#0pmos@13_poly-left##8 sel_B77748#1pin@106_polysilicon-1 9.455
R44 sel_B77748#1pin@106_polysilicon-1 sel_B77748#1pin@106_polysilicon-1##0 8.783
R45 sel_B77748#1pin@106_polysilicon-1##0 sel_B77748#1pin@106_polysilicon-1##1 8.783
R46 sel_B77748#1pin@106_polysilicon-1##1 sel_B77748#2nmos@13_poly-right 8.783
R47 sel_B77748#1pin@106_polysilicon-1 sel_B77748#1pin@106_polysilicon-1##0 9.3
R48 sel_B77748#1pin@106_polysilicon-1##0 sel_B77748#1pin@106_polysilicon-1##1 9.3
R49 sel_B77748#1pin@106_polysilicon-1##1 sel_B77748 9.3
R50 net@190#11pmos@16_poly-left net@190#11pmos@16_poly-left##0 9.688
C23 net@190#11pmos@16_poly-left##0 0 0.1fF
R51 net@190#11pmos@16_poly-left##0 net@190#11pmos@16_poly-left##1 9.688
C24 net@190#11pmos@16_poly-left##1 0 0.1fF
R52 net@190#11pmos@16_poly-left##1 net@190#11pmos@16_poly-left##2 9.688
C25 net@190#11pmos@16_poly-left##2 0 0.1fF
R53 net@190#11pmos@16_poly-left##2 net@190#11pmos@16_poly-left##3 9.688
C26 net@190#11pmos@16_poly-left##3 0 0.1fF
R54 net@190#11pmos@16_poly-left##3 net@190#11pmos@16_poly-left##4 9.688
C27 net@190#11pmos@16_poly-left##4 0 0.1fF
R55 net@190#11pmos@16_poly-left##4 net@190#11pmos@16_poly-left##5 9.688
C28 net@190#11pmos@16_poly-left##5 0 0.1fF
R56 net@190#11pmos@16_poly-left##5 net@190#11pmos@16_poly-left##6 9.688
C29 net@190#11pmos@16_poly-left##6 0 0.1fF
R57 net@190#11pmos@16_poly-left##6 net@190#12pin@120_polysilicon-1 9.688
R58 net@190#12pin@120_polysilicon-1 net@190#12pin@120_polysilicon-1##0 8.68
R59 net@190#12pin@120_polysilicon-1##0 net@190#12pin@120_polysilicon-1##1 8.68
R60 net@190#12pin@120_polysilicon-1##1 net@190#12pin@120_polysilicon-1##2 8.68
R61 net@190#12pin@120_polysilicon-1##2 net@190#12pin@120_polysilicon-1##3 8.68
R62 net@190#12pin@120_polysilicon-1##3 net@190#13nmos@16_poly-right 8.68
R63 net@190#12pin@120_polysilicon-1 net@190#12pin@120_polysilicon-1##0 6.717
R64 net@190#12pin@120_polysilicon-1##0 net@190#12pin@120_polysilicon-1##1 6.717
R65 net@190#12pin@120_polysilicon-1##1 net@190 6.717
R66 net@223#11pmos@15_poly-left net@223#11pmos@15_poly-left##0 9.079
R67 net@223#11pmos@15_poly-left##0 net@223#11pmos@15_poly-left##1 9.079
R68 net@223#11pmos@15_poly-left##1 net@223#11pmos@15_poly-left##2 9.079
R69 net@223#11pmos@15_poly-left##2 net@223#11pmos@15_poly-left##3 9.079
R70 net@223#11pmos@15_poly-left##3 net@223#11pmos@15_poly-left##4 9.079
R71 net@223#11pmos@15_poly-left##4 net@223#11pmos@15_poly-left##5 9.079
R72 net@223#11pmos@15_poly-left##5 net@223#12pin@121_polysilicon-1 9.079
R73 net@223#12pin@121_polysilicon-1 net@223#12pin@121_polysilicon-1##0 9.558
R74 net@223#12pin@121_polysilicon-1##0 net@223#12pin@121_polysilicon-1##1 9.558
R75 net@223#12pin@121_polysilicon-1##1 net@223#12pin@121_polysilicon-1##2 9.558
R76 net@223#12pin@121_polysilicon-1##2 net@223#12pin@121_polysilicon-1##3 9.558
R77 net@223#12pin@121_polysilicon-1##3 net@223#12pin@121_polysilicon-1##4 9.558
R78 net@223#12pin@121_polysilicon-1##4 net@223#13nmos@15_poly-right 9.558
R79 net@223#12pin@121_polysilicon-1 net@223#12pin@121_polysilicon-1##0 9.3
R80 net@223#12pin@121_polysilicon-1##0 net@223#12pin@121_polysilicon-1##1 9.3
R81 net@223#12pin@121_polysilicon-1##1 net@223 9.3
R82 sel_B77748#5pmos@17_poly-left sel_B77748#5pmos@17_poly-left##0 7.75
R83 sel_B77748#5pmos@17_poly-left##0 sel_B77748#5pmos@17_poly-left##1 7.75
R84 sel_B77748#5pmos@17_poly-left##1 sel_B77748#5pmos@17_poly-left##2 7.75
R85 sel_B77748#5pmos@17_poly-left##2 sel_B77748#6pin@140_polysilicon-1 7.75
R86 sel_B77748#6pin@140_polysilicon-1 sel_B77748#6pin@140_polysilicon-1##0 9.92
R87 sel_B77748#6pin@140_polysilicon-1##0 sel_B77748#6pin@140_polysilicon-1##1 9.92
R88 sel_B77748#6pin@140_polysilicon-1##1 sel_B77748#6pin@140_polysilicon-1##2 9.92
R89 sel_B77748#6pin@140_polysilicon-1##2 sel_B77748#6pin@140_polysilicon-1##3 9.92
R90 sel_B77748#6pin@140_polysilicon-1##3 sel_B77748#7nmos@17_poly-right 9.92
R91 sel_B77748#6pin@140_polysilicon-1 sel_B77748#6pin@140_polysilicon-1##0 9.3
R92 sel_B77748#6pin@140_polysilicon-1##0 sel_B77748 9.3
R93 net@294#4pmos@11_poly-left net@294#4pmos@11_poly-left##0 9.455
R94 net@294#4pmos@11_poly-left##0 net@294#4pmos@11_poly-left##1 9.455
R95 net@294#4pmos@11_poly-left##1 net@294#4pmos@11_poly-left##2 9.455
R96 net@294#4pmos@11_poly-left##2 net@294#4pmos@11_poly-left##3 9.455
R97 net@294#4pmos@11_poly-left##3 net@294#4pmos@11_poly-left##4 9.455
R98 net@294#4pmos@11_poly-left##4 net@294#4pmos@11_poly-left##5 9.455
R99 net@294#4pmos@11_poly-left##5 net@294#4pmos@11_poly-left##6 9.455
R100 net@294#4pmos@11_poly-left##6 net@294#4pmos@11_poly-left##7 9.455
R101 net@294#4pmos@11_poly-left##7 net@294#4pmos@11_poly-left##8 9.455
R102 net@294#4pmos@11_poly-left##8 net@294#5pin@141_polysilicon-1 9.455
R103 net@294#5pin@141_polysilicon-1 net@294#5pin@141_polysilicon-1##0 8.783
R104 net@294#5pin@141_polysilicon-1##0 net@294#5pin@141_polysilicon-1##1 8.783
R105 net@294#5pin@141_polysilicon-1##1 net@294#6nmos@11_poly-right 8.783
R106 net@294#5pin@141_polysilicon-1 net@294#5pin@141_polysilicon-1##0 9.3
R107 net@294#5pin@141_polysilicon-1##0 net@294 9.3
.ENDS IE0311_B77748_B45211_II2024__MUX_2_1_NAND2_10_10_B77748_B45211

*** TOP LEVEL CELL: MUX_2_1_NAND2_10_10_sim{lay}
XMUX_2_1_@0 Va Vb GND sel VDD Vout IE0311_B77748_B45211_II2024__MUX_2_1_NAND2_10_10_B77748_B45211
** Extracted Parasitic Capacitors ***
C0 Va 0 0.953fF
C1 Vb 0 2.985fF
C2 Vout 0 1.651fF
C3 GND 0 2.154fF
C4 sel 0 1.27fF
C5 VDD 0 1.243fF
** Extracted Parasitic Resistors ***

* Spice Code nodes in cell cell 'MUX_2_1_NAND2_10_10_sim{lay}'
.include C:\Users\vboxuser\Documents\spice.txt
* Definir la fuente de alimentacion
VDD VDD 0 DC 5
*Tierra
VGND GND DC 0
.tran 0 100n
VS   sel   0 PULSE 0 5 2n 0.1n 0.1n  25n 50n
VA   Va   0 PULSE 0 5 5n 0.1n 0.1n  10n 20n
* Para probar despues el funcionamiento
VB   Vb   0 PULSE 0 5 40n 0.1n 0.1n  10n 20n
* Medicion del retardo de subida
.MEAS t_rise time TRIG V(Va)=2.5 RISE=2 TARG V(Vout)=2.5 RISE=2
.MEAS t_fall time TRIG V(Va)=2.5 FALL=1 TARG V(Vout)=2.5 FALL=1
.END
