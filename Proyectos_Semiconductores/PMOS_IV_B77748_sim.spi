*** SPICE deck for cell PMOS_IV_B77748_sim{lay} from library IE0311_B77748_II2024
*** Created on dom sep 15, 2024 02:30:54
*** Last revised on dom sep 15, 2024 19:37:18
*** Written on dom sep 15, 2024 19:38:03 by Electric VLSI Design System, version 9.07
*** Layout tech: mocmos, foundry MOSIS
*** UC SPICE *** , MIN_RESIST 4.0, MIN_CAPAC 0.1FF
***    P-Active:	areacap=0.9FF/um^2,	edgecap=0.0FF/um,	res=2.5ohms/sq
***    N-Active:	areacap=0.9FF/um^2,	edgecap=0.0FF/um,	res=3.0ohms/sq
***    Polysilicon-1:	areacap=0.1467FF/um^2,	edgecap=0.0608FF/um,	res=6.2ohms/sq
***    Polysilicon-2:	areacap=1.0FF/um^2,	edgecap=0.0FF/um,	res=50.0ohms/sq
***    Transistor-Poly:	areacap=0.09FF/um^2,	edgecap=0.0FF/um,	res=2.5ohms/sq
***    Poly-Cut:	areacap=0.0FF/um^2,	edgecap=0.0FF/um,	res=2.2ohms/sq
***    Active-Cut:	areacap=0.0FF/um^2,	edgecap=0.0FF/um,	res=2.5ohms/sq
***    Metal-1:	areacap=0.1209FF/um^2,	edgecap=0.1104FF/um,	res=0.078ohms/sq
***    Via1:	areacap=0.0FF/um^2,	edgecap=0.0FF/um,	res=1.0ohms/sq
***    Metal-2:	areacap=0.0843FF/um^2,	edgecap=0.0974FF/um,	res=0.078ohms/sq
***    Via2:	areacap=0.0FF/um^2,	edgecap=0.0FF/um,	res=0.9ohms/sq
***    Metal-3:	areacap=0.0843FF/um^2,	edgecap=0.0974FF/um,	res=0.078ohms/sq
***    Via3:	areacap=0.0FF/um^2,	edgecap=0.0FF/um,	res=0.8ohms/sq
***    Metal-4:	areacap=0.0843FF/um^2,	edgecap=0.0974FF/um,	res=0.078ohms/sq
***    Via4:	areacap=0.0FF/um^2,	edgecap=0.0FF/um,	res=0.8ohms/sq
***    Metal-5:	areacap=0.0843FF/um^2,	edgecap=0.0974FF/um,	res=0.078ohms/sq
***    Via5:	areacap=0.0FF/um^2,	edgecap=0.0FF/um,	res=0.8ohms/sq
***    Metal-6:	areacap=0.0423FF/um^2,	edgecap=0.1273FF/um,	res=0.036ohms/sq
***    Hi-Res:	areacap=0.0FF/um^2,	edgecap=0.0FF/um,	res=1.0ohms/sq

*** SUBCIRCUIT IE0311_B77748_II2024__PMOS_IV_B77748 FROM CELL PMOS_IV_B77748{lay}
.SUBCKT IE0311_B77748_II2024__PMOS_IV_B77748 d_B77748 g_B77748 s_B77748 vdd
Mpmos@0 s_B77748 g_B77748#0pmos@0_poly-left d_B77748 vdd PMOS L=0.4U W=2U AS=2.4P AD=2.4P PS=6.4U PD=6.4U
** Extracted Parasitic Capacitors ***
C0 d_B77748 0 0.587fF
C1 s_B77748 0 0.587fF
** Extracted Parasitic Resistors ***
R0 g_B77748 g_B77748##0 6.975
R1 g_B77748##0 g_B77748#0pmos@0_poly-left 6.975
.ENDS IE0311_B77748_II2024__PMOS_IV_B77748

*** TOP LEVEL CELL: PMOS_IV_B77748_sim{lay}
XPMOS_IV_@0 Vd Vg Vs VDD IE0311_B77748_II2024__PMOS_IV_B77748
** Extracted Parasitic Capacitors ***
C0 Vd 0 0.381fF
C1 Vg 0 0.476fF
C2 Vs 0 0.381fF
C3 VDD 0 0.968fF
** Extracted Parasitic Resistors ***

* Spice Code nodes in cell cell 'PMOS_IV_B77748_sim{lay}'
.include \Universidad\DispositivosSemiconductores\Lab1\spice.txt ;
VGND GND 0 DC 0 ;
Vx_var Vg Vs 0 DC {Vgs} ;
Vs Vs 0 DC 5 ;
Vds Vd Vs DC 0 ;
.DC Vds 0 -5 -1m ;
.step param Vgs -5 0 1 ;
.END
