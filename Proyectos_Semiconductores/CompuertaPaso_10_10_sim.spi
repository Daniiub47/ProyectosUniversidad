*** SPICE deck for cell CompuertaPaso_10_10_sim{lay} from library IE0311_B77748_B45211_II2024(1)
*** Created on Sat Nov 30, 2024 16:56:52
*** Last revised on Sat Nov 30, 2024 18:17:43
*** Written on Sat Nov 30, 2024 18:17:59 by Electric VLSI Design System, version 9.07
*** Layout tech: mocmos, foundry MOSIS
*** UC SPICE *** , MIN_RESIST 4.0, MIN_CAPAC 0.1FF
***    P-Active:	areacap=0.9FF/um^2,	edgecap=0.0FF/um,	res=2.5ohms/sq
***    N-Active:	areacap=0.9FF/um^2,	edgecap=0.0FF/um,	res=3.0ohms/sq
***    Polysilicon-1:	areacap=0.1467FF/um^2,	edgecap=0.0608FF/um,	res=6.2ohms/sq
***    Polysilicon-2:	areacap=1.0FF/um^2,	edgecap=0.0FF/um,	res=50.0ohms/sq
***    Transistor-Poly:	areacap=0.09FF/um^2,	edgecap=0.0FF/um,	res=2.5ohms/sq
***    Poly-Cut:	areacap=0.0FF/um^2,	edgecap=0.0FF/um,	res=2.2ohms/sq
***    Active-Cut:	areacap=0.0FF/um^2,	edgecap=0.0FF/um,	res=2.5ohms/sq
***    Metal-1:	areacap=0.1209FF/um^2,	edgecap=0.1104FF/um,	res=0.078ohms/sq
***    Via1:	areacap=0.0FF/um^2,	edgecap=0.0FF/um,	res=1.0ohms/sq
***    Metal-2:	areacap=0.0843FF/um^2,	edgecap=0.0974FF/um,	res=0.078ohms/sq
***    Via2:	areacap=0.0FF/um^2,	edgecap=0.0FF/um,	res=0.9ohms/sq
***    Metal-3:	areacap=0.0843FF/um^2,	edgecap=0.0974FF/um,	res=0.078ohms/sq
***    Via3:	areacap=0.0FF/um^2,	edgecap=0.0FF/um,	res=0.8ohms/sq
***    Metal-4:	areacap=0.0843FF/um^2,	edgecap=0.0974FF/um,	res=0.078ohms/sq
***    Via4:	areacap=0.0FF/um^2,	edgecap=0.0FF/um,	res=0.8ohms/sq
***    Metal-5:	areacap=0.0843FF/um^2,	edgecap=0.0974FF/um,	res=0.078ohms/sq
***    Via5:	areacap=0.0FF/um^2,	edgecap=0.0FF/um,	res=0.8ohms/sq
***    Metal-6:	areacap=0.0423FF/um^2,	edgecap=0.1273FF/um,	res=0.036ohms/sq
***    Hi-Res:	areacap=0.0FF/um^2,	edgecap=0.0FF/um,	res=1.0ohms/sq

*** SUBCIRCUIT IE0311_B77748_B45211_II2024_1___CompuertaPaso_10_10_B77748_B45211 FROM CELL IE0311_B77748_B45211_II2024(1):CompuertaPaso_10_10_B77748_B45211{lay}
.SUBCKT IE0311_B77748_B45211_II2024_1___CompuertaPaso_10_10_B77748_B45211 A_B77748 gnd sel_B77748 sel_b_B77748 vdd Y_B77748
Mnmos@0 A_B77748 sel_B77748#1nmos@0_poly-left Y_B77748 gnd NMOS L=0.4U W=2U AS=2.8P AD=2.8P PS=6.8U PD=6.8U
Mpmos@0 A_B77748 sel_b_B77748#0pmos@0_poly-right Y_B77748 vdd PMOS L=0.4U W=2U AS=2.8P AD=2.8P PS=6.8U PD=6.8U
** Extracted Parasitic Capacitors ***
C0 A_B77748 0 3.778fF
C1 Y_B77748 0 3.778fF
C2 sel_B77748#0pin@17_polysilicon-1 0 0.18fF
C3 sel_b_B77748#1pin@18_polysilicon-1 0 0.18fF
** Extracted Parasitic Resistors ***
R0 sel_B77748#0pin@17_polysilicon-1 sel_B77748#0pin@17_polysilicon-1##0 9.688
R1 sel_B77748#0pin@17_polysilicon-1##0 sel_B77748#0pin@17_polysilicon-1##1 9.688
R2 sel_B77748#0pin@17_polysilicon-1##1 sel_B77748#0pin@17_polysilicon-1##2 9.688
R3 sel_B77748#0pin@17_polysilicon-1##2 sel_B77748#1nmos@0_poly-left 9.688
R4 sel_B77748#0pin@17_polysilicon-1 sel_B77748#0pin@17_polysilicon-1##0 9.3
R5 sel_B77748#0pin@17_polysilicon-1##0 sel_B77748#0pin@17_polysilicon-1##1 9.3
R6 sel_B77748#0pin@17_polysilicon-1##1 sel_B77748#0pin@17_polysilicon-1##2 9.3
R7 sel_B77748#0pin@17_polysilicon-1##2 sel_B77748#0pin@17_polysilicon-1##3 9.3
R8 sel_B77748#0pin@17_polysilicon-1##3 sel_B77748 9.3
R9 sel_b_B77748#0pmos@0_poly-right sel_b_B77748#0pmos@0_poly-right##0 9.688
R10 sel_b_B77748#0pmos@0_poly-right##0 sel_b_B77748#0pmos@0_poly-right##1 9.688
R11 sel_b_B77748#0pmos@0_poly-right##1 sel_b_B77748#0pmos@0_poly-right##2 9.688
R12 sel_b_B77748#0pmos@0_poly-right##2 sel_b_B77748#1pin@18_polysilicon-1 9.688
R13 sel_b_B77748#1pin@18_polysilicon-1 sel_b_B77748#1pin@18_polysilicon-1##0 9.3
R14 sel_b_B77748#1pin@18_polysilicon-1##0 sel_b_B77748#1pin@18_polysilicon-1##1 9.3
R15 sel_b_B77748#1pin@18_polysilicon-1##1 sel_b_B77748#1pin@18_polysilicon-1##2 9.3
R16 sel_b_B77748#1pin@18_polysilicon-1##2 sel_b_B77748#1pin@18_polysilicon-1##3 9.3
R17 sel_b_B77748#1pin@18_polysilicon-1##3 sel_b_B77748 9.3
.ENDS IE0311_B77748_B45211_II2024_1___CompuertaPaso_10_10_B77748_B45211

*** TOP LEVEL CELL: IE0311_B77748_B45211_II2024(1):CompuertaPaso_10_10_sim{lay}
XCompuert@0 Vin GND sel sel_b VDD Vout IE0311_B77748_B45211_II2024_1___CompuertaPaso_10_10_B77748_B45211
** Extracted Parasitic Capacitors ***
C0 Vin 0 0.826fF
C1 Vout 0 0.762fF
C2 GND 0 0.87fF
C3 sel 0 0.889fF
C4 sel_b 0 0.889fF
C5 VDD 0 1.118fF
** Extracted Parasitic Resistors ***

* Spice Code nodes in cell cell 'IE0311_B77748_B45211_II2024(1):CompuertaPaso_10_10_sim{lay}'
.include C:\Users\vboxuser\Documents\spice.txt
* Definir la fuente de alimentaciÃ³n
VDD VDD 0 DC 5
*Tierra
VGND GND DC 0
* Análisis transitorio para 50ns
.TRAN 0 50n
*Poner Vsel como una onda cuadrada de 10ns de periodo
VSEL   sel   0 PULSE 0 5 2n 0.1n 0.1n  10n 20n
*sel_b es el opuesto de sel
VSELB sel_b 0 PULSE 5 0 2n 0.1n 0.1n  10n 20n
*La señal de entrada es una onda cuadrada de 14ns de periodo
VA       Vin      0 PULSE 5 0 10n 0.1n 0.1n  7n 14n
.END
.END
